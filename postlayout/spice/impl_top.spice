* NGSPICE file created from impl_top.ext - technology: sky130A

* Black-box entry subcircuit for sky130_fd_sc_hd__tapvpwrvgnd_1 abstract view
.subckt sky130_fd_sc_hd__tapvpwrvgnd_1 VGND VPWR
.ends

* Black-box entry subcircuit for sky130_ef_sc_hd__decap_40_12 abstract view
.subckt sky130_ef_sc_hd__decap_40_12 VPWR VGND VPB VNB
.ends

* Black-box entry subcircuit for sky130_fd_sc_hd__fill_4 abstract view
.subckt sky130_fd_sc_hd__fill_4 VGND VNB VPB VPWR
.ends

* Black-box entry subcircuit for sky130_fd_sc_hd__fill_1 abstract view
.subckt sky130_fd_sc_hd__fill_1 VGND VNB VPB VPWR
.ends

* Black-box entry subcircuit for sky130_fd_sc_hd__fill_2 abstract view
.subckt sky130_fd_sc_hd__fill_2 VGND VNB VPB VPWR
.ends

* Black-box entry subcircuit for sky130_fd_sc_hd__dfxtp_1 abstract view
.subckt sky130_fd_sc_hd__dfxtp_1 CLK D VGND VNB VPB VPWR Q
.ends

* Black-box entry subcircuit for sky130_fd_sc_hd__a2111o_1 abstract view
.subckt sky130_fd_sc_hd__a2111o_1 A1 A2 B1 C1 D1 VGND VNB VPB VPWR X
.ends

* Black-box entry subcircuit for sky130_fd_sc_hd__o211a_1 abstract view
.subckt sky130_fd_sc_hd__o211a_1 A1 A2 B1 C1 VGND VNB VPB VPWR X
.ends

* Black-box entry subcircuit for sky130_fd_sc_hd__a31o_1 abstract view
.subckt sky130_fd_sc_hd__a31o_1 A1 A2 A3 B1 VGND VNB VPB VPWR X
.ends

* Black-box entry subcircuit for sky130_fd_sc_hd__dlygate4sd3_1 abstract view
.subckt sky130_fd_sc_hd__dlygate4sd3_1 A VGND VNB VPB VPWR X
.ends

* Black-box entry subcircuit for sky130_fd_sc_hd__and2_1 abstract view
.subckt sky130_fd_sc_hd__and2_1 A B VGND VNB VPB VPWR X
.ends

* Black-box entry subcircuit for sky130_fd_sc_hd__or4bb_1 abstract view
.subckt sky130_fd_sc_hd__or4bb_1 A B C_N D_N VGND VNB VPB VPWR X
.ends

* Black-box entry subcircuit for sky130_fd_sc_hd__mux2_1 abstract view
.subckt sky130_fd_sc_hd__mux2_1 A0 A1 S VGND VNB VPB VPWR X
.ends

* Black-box entry subcircuit for sky130_fd_sc_hd__buf_2 abstract view
.subckt sky130_fd_sc_hd__buf_2 A VGND VNB VPB VPWR X
.ends

* Black-box entry subcircuit for sky130_fd_sc_hd__diode_2 abstract view
.subckt sky130_fd_sc_hd__diode_2 DIODE VGND VNB VPB VPWR
.ends

* Black-box entry subcircuit for sky130_fd_sc_hd__or2_1 abstract view
.subckt sky130_fd_sc_hd__or2_1 A B VGND VNB VPB VPWR X
.ends

* Black-box entry subcircuit for sky130_fd_sc_hd__clkbuf_16 abstract view
.subckt sky130_fd_sc_hd__clkbuf_16 A VGND VNB VPB VPWR X
.ends

* Black-box entry subcircuit for sky130_fd_sc_hd__nor3_1 abstract view
.subckt sky130_fd_sc_hd__nor3_1 A B C VGND VNB VPB VPWR Y
.ends

* Black-box entry subcircuit for sky130_fd_sc_hd__decap_3 abstract view
.subckt sky130_fd_sc_hd__decap_3 VGND VNB VPB VPWR
.ends

* Black-box entry subcircuit for sky130_fd_sc_hd__nor2_1 abstract view
.subckt sky130_fd_sc_hd__nor2_1 A B VGND VNB VPB VPWR Y
.ends

* Black-box entry subcircuit for sky130_fd_sc_hd__or4_1 abstract view
.subckt sky130_fd_sc_hd__or4_1 A B C D VGND VNB VPB VPWR X
.ends

* Black-box entry subcircuit for sky130_fd_sc_hd__or4b_1 abstract view
.subckt sky130_fd_sc_hd__or4b_1 A B C D_N VGND VNB VPB VPWR X
.ends

* Black-box entry subcircuit for sky130_fd_sc_hd__a22o_1 abstract view
.subckt sky130_fd_sc_hd__a22o_1 A1 A2 B1 B2 VGND VNB VPB VPWR X
.ends

* Black-box entry subcircuit for sky130_fd_sc_hd__o21ai_1 abstract view
.subckt sky130_fd_sc_hd__o21ai_1 A1 A2 B1 VGND VNB VPB VPWR Y
.ends

* Black-box entry subcircuit for sky130_fd_sc_hd__nand2_1 abstract view
.subckt sky130_fd_sc_hd__nand2_1 A B VGND VNB VPB VPWR Y
.ends

* Black-box entry subcircuit for sky130_fd_sc_hd__nor2_4 abstract view
.subckt sky130_fd_sc_hd__nor2_4 A B VGND VNB VPB VPWR Y
.ends

* Black-box entry subcircuit for sky130_fd_sc_hd__and4_1 abstract view
.subckt sky130_fd_sc_hd__and4_1 A B C D VGND VNB VPB VPWR X
.ends

* Black-box entry subcircuit for sky130_fd_sc_hd__a21o_1 abstract view
.subckt sky130_fd_sc_hd__a21o_1 A1 A2 B1 VGND VNB VPB VPWR X
.ends

* Black-box entry subcircuit for sky130_fd_sc_hd__and3_1 abstract view
.subckt sky130_fd_sc_hd__and3_1 A B C VGND VNB VPB VPWR X
.ends

* Black-box entry subcircuit for sky130_fd_sc_hd__inv_6 abstract view
.subckt sky130_fd_sc_hd__inv_6 A VGND VNB VPB VPWR Y
.ends

* Black-box entry subcircuit for sky130_fd_sc_hd__dfxtp_2 abstract view
.subckt sky130_fd_sc_hd__dfxtp_2 CLK D VGND VNB VPB VPWR Q
.ends

* Black-box entry subcircuit for sky130_fd_sc_hd__or4_2 abstract view
.subckt sky130_fd_sc_hd__or4_2 A B C D VGND VNB VPB VPWR X
.ends

* Black-box entry subcircuit for sky130_fd_sc_hd__clkinvlp_4 abstract view
.subckt sky130_fd_sc_hd__clkinvlp_4 A VGND VNB VPB VPWR Y
.ends

* Black-box entry subcircuit for sky130_fd_sc_hd__fill_8 abstract view
.subckt sky130_fd_sc_hd__fill_8 VGND VNB VPB VPWR
.ends

* Black-box entry subcircuit for sky130_fd_sc_hd__a221o_1 abstract view
.subckt sky130_fd_sc_hd__a221o_1 A1 A2 B1 B2 C1 VGND VNB VPB VPWR X
.ends

* Black-box entry subcircuit for sky130_fd_sc_hd__or3_1 abstract view
.subckt sky130_fd_sc_hd__or3_1 A B C VGND VNB VPB VPWR X
.ends

* Black-box entry subcircuit for sky130_fd_sc_hd__and3b_1 abstract view
.subckt sky130_fd_sc_hd__and3b_1 A_N B C VGND VNB VPB VPWR X
.ends

* Black-box entry subcircuit for sky130_fd_sc_hd__nand4b_1 abstract view
.subckt sky130_fd_sc_hd__nand4b_1 A_N B C D VGND VNB VPB VPWR Y
.ends

* Black-box entry subcircuit for sky130_fd_sc_hd__inv_4 abstract view
.subckt sky130_fd_sc_hd__inv_4 A VGND VNB VPB VPWR Y
.ends

* Black-box entry subcircuit for sky130_fd_sc_hd__o221a_1 abstract view
.subckt sky130_fd_sc_hd__o221a_1 A1 A2 B1 B2 C1 VGND VNB VPB VPWR X
.ends

* Black-box entry subcircuit for sky130_fd_sc_hd__clkinv_2 abstract view
.subckt sky130_fd_sc_hd__clkinv_2 A VGND VNB VPB VPWR Y
.ends

* Black-box entry subcircuit for sky130_fd_sc_hd__a21oi_1 abstract view
.subckt sky130_fd_sc_hd__a21oi_1 A1 A2 B1 VGND VNB VPB VPWR Y
.ends

* Black-box entry subcircuit for sky130_fd_sc_hd__clkbuf_8 abstract view
.subckt sky130_fd_sc_hd__clkbuf_8 A VGND VNB VPB VPWR X
.ends

* Black-box entry subcircuit for sky130_fd_sc_hd__o21ba_1 abstract view
.subckt sky130_fd_sc_hd__o21ba_1 A1 A2 B1_N VGND VNB VPB VPWR X
.ends

* Black-box entry subcircuit for sky130_fd_sc_hd__nand3_1 abstract view
.subckt sky130_fd_sc_hd__nand3_1 A B C VGND VNB VPB VPWR Y
.ends

* Black-box entry subcircuit for sky130_fd_sc_hd__o31a_2 abstract view
.subckt sky130_fd_sc_hd__o31a_2 A1 A2 A3 B1 VGND VNB VPB VPWR X
.ends

* Black-box entry subcircuit for sky130_fd_sc_hd__clkbuf_1 abstract view
.subckt sky130_fd_sc_hd__clkbuf_1 A VGND VNB VPB VPWR X
.ends

* Black-box entry subcircuit for sky130_fd_sc_hd__buf_4 abstract view
.subckt sky130_fd_sc_hd__buf_4 A VGND VNB VPB VPWR X
.ends

* Black-box entry subcircuit for sky130_fd_sc_hd__buf_1 abstract view
.subckt sky130_fd_sc_hd__buf_1 A VGND VNB VPB VPWR X
.ends

* Black-box entry subcircuit for sky130_fd_sc_hd__o311a_2 abstract view
.subckt sky130_fd_sc_hd__o311a_2 A1 A2 A3 B1 C1 VGND VNB VPB VPWR X
.ends

* Black-box entry subcircuit for sky130_fd_sc_hd__xor2_1 abstract view
.subckt sky130_fd_sc_hd__xor2_1 A B VGND VNB VPB VPWR X
.ends

* Black-box entry subcircuit for sky130_fd_sc_hd__nor2_2 abstract view
.subckt sky130_fd_sc_hd__nor2_2 A B VGND VNB VPB VPWR Y
.ends

* Black-box entry subcircuit for sky130_fd_sc_hd__inv_2 abstract view
.subckt sky130_fd_sc_hd__inv_2 A VGND VNB VPB VPWR Y
.ends

* Black-box entry subcircuit for sky130_fd_sc_hd__nand2_2 abstract view
.subckt sky130_fd_sc_hd__nand2_2 A B VGND VNB VPB VPWR Y
.ends

* Black-box entry subcircuit for sky130_fd_sc_hd__and2_2 abstract view
.subckt sky130_fd_sc_hd__and2_2 A B VGND VNB VPB VPWR X
.ends

* Black-box entry subcircuit for sky130_fd_sc_hd__a21bo_2 abstract view
.subckt sky130_fd_sc_hd__a21bo_2 A1 A2 B1_N VGND VNB VPB VPWR X
.ends

* Black-box entry subcircuit for sky130_fd_sc_hd__or4_4 abstract view
.subckt sky130_fd_sc_hd__or4_4 A B C D VGND VNB VPB VPWR X
.ends

* Black-box entry subcircuit for sky130_fd_sc_hd__a211oi_4 abstract view
.subckt sky130_fd_sc_hd__a211oi_4 A1 A2 B1 C1 VGND VNB VPB VPWR Y
.ends

* Black-box entry subcircuit for sky130_fd_sc_hd__nor4_1 abstract view
.subckt sky130_fd_sc_hd__nor4_1 A B C D VGND VNB VPB VPWR Y
.ends

* Black-box entry subcircuit for sky130_fd_sc_hd__and2b_1 abstract view
.subckt sky130_fd_sc_hd__and2b_1 A_N B VGND VNB VPB VPWR X
.ends

* Black-box entry subcircuit for sky130_fd_sc_hd__dfxtp_4 abstract view
.subckt sky130_fd_sc_hd__dfxtp_4 CLK D VGND VNB VPB VPWR Q
.ends

* Black-box entry subcircuit for sky130_fd_sc_hd__o31a_1 abstract view
.subckt sky130_fd_sc_hd__o31a_1 A1 A2 A3 B1 VGND VNB VPB VPWR X
.ends

* Black-box entry subcircuit for sky130_fd_sc_hd__and4_2 abstract view
.subckt sky130_fd_sc_hd__and4_2 A B C D VGND VNB VPB VPWR X
.ends

* Black-box entry subcircuit for sky130_fd_sc_hd__a32o_1 abstract view
.subckt sky130_fd_sc_hd__a32o_1 A1 A2 A3 B1 B2 VGND VNB VPB VPWR X
.ends

* Black-box entry subcircuit for sky130_fd_sc_hd__nor4_4 abstract view
.subckt sky130_fd_sc_hd__nor4_4 A B C D VGND VNB VPB VPWR Y
.ends

.subckt impl_top VGND VPWR clk led[0] led[1] led[2] led[3] led[4] led[5] led[6] led[7]
+ sw_0 sw_1 uart_rxd uart_txd
XTAP_TAPCELL_ROW_37_401 VGND VPWR sky130_fd_sc_hd__tapvpwrvgnd_1
XFILLER_52_29 VPWR VGND VPWR VGND sky130_ef_sc_hd__decap_40_12
XFILLER_22_133 VGND VGND VPWR VPWR sky130_fd_sc_hd__fill_4
XFILLER_22_177 VPWR VGND VPWR VGND sky130_ef_sc_hd__decap_40_12
XFILLER_18_406 VGND VGND VPWR VPWR sky130_fd_sc_hd__fill_1
XFILLER_45_269 VGND VGND VPWR VPWR sky130_fd_sc_hd__fill_2
XFILLER_45_225 VPWR VGND VPWR VGND sky130_ef_sc_hd__decap_40_12
X_501_ _516_/CLK _501_/D VGND VGND VPWR VPWR _501_/Q sky130_fd_sc_hd__dfxtp_1
XFILLER_26_85 VPWR VGND VPWR VGND sky130_ef_sc_hd__decap_40_12
XFILLER_26_41 VPWR VGND VPWR VGND sky130_ef_sc_hd__decap_40_12
X_432_ _434_/A _434_/B _485_/A _432_/C1 _447_/B VGND VGND VPWR VPWR _433_/B sky130_fd_sc_hd__a2111o_1
XFILLER_13_111 VGND VGND VPWR VPWR sky130_fd_sc_hd__fill_1
X_363_ _364_/A _356_/Y _374_/C _362_/X VGND VGND VPWR VPWR _515_/D sky130_fd_sc_hd__o211a_1
XFILLER_9_137 VPWR VGND VPWR VGND sky130_ef_sc_hd__decap_40_12
X_294_ _273_/A _434_/B _294_/A3 _433_/A VGND VGND VPWR VPWR _294_/X sky130_fd_sc_hd__a31o_1
XFILLER_51_217 VGND VGND VPWR VPWR sky130_fd_sc_hd__fill_4
XFILLER_59_317 VPWR VGND VPWR VGND sky130_ef_sc_hd__decap_40_12
XFILLER_63_39 VPWR VGND VPWR VGND sky130_ef_sc_hd__decap_40_12
XFILLER_42_217 VPWR VGND VPWR VGND sky130_ef_sc_hd__decap_40_12
XTAP_TAPCELL_ROW_40_418 VGND VPWR sky130_fd_sc_hd__tapvpwrvgnd_1
Xhold170 _526_/Q VGND VGND VPWR VPWR _390_/A sky130_fd_sc_hd__dlygate4sd3_1
XFILLER_2_357 VGND VGND VPWR VPWR sky130_fd_sc_hd__fill_4
XFILLER_12_65 VPWR VGND VPWR VGND sky130_ef_sc_hd__decap_40_12
XFILLER_58_361 VGND VGND VPWR VPWR sky130_fd_sc_hd__fill_2
XFILLER_37_51 VGND VGND VPWR VPWR sky130_fd_sc_hd__fill_4
XTAP_TAPCELL_ROW_5_173 VGND VPWR sky130_fd_sc_hd__tapvpwrvgnd_1
X_346_ _364_/A _374_/A _273_/A _345_/X VGND VGND VPWR VPWR _508_/D sky130_fd_sc_hd__o211a_1
X_415_ _415_/A _421_/D VGND VGND VPWR VPWR _417_/A sky130_fd_sc_hd__and2_1
X_277_ _277_/A _480_/B _474_/A _480_/A VGND VGND VPWR VPWR _278_/D sky130_fd_sc_hd__or4bb_1
XFILLER_56_309 VPWR VGND VPWR VGND sky130_ef_sc_hd__decap_40_12
XFILLER_49_361 VPWR VGND VPWR VGND sky130_ef_sc_hd__decap_40_12
XTAP_TAPCELL_ROW_19_275 VGND VPWR sky130_fd_sc_hd__tapvpwrvgnd_1
XTAP_TAPCELL_ROW_62_576 VGND VPWR sky130_fd_sc_hd__tapvpwrvgnd_1
XFILLER_59_169 VPWR VGND VPWR VGND sky130_ef_sc_hd__decap_40_12
XFILLER_59_125 VPWR VGND VPWR VGND sky130_ef_sc_hd__decap_40_12
XTAP_TAPCELL_ROW_2_154 VGND VPWR sky130_fd_sc_hd__tapvpwrvgnd_1
XTAP_TAPCELL_ROW_53_510 VGND VPWR sky130_fd_sc_hd__tapvpwrvgnd_1
XFILLER_15_217 VGND VGND VPWR VPWR sky130_fd_sc_hd__fill_4
XFILLER_7_405 VGND VGND VPWR VPWR sky130_fd_sc_hd__fill_2
XFILLER_38_309 VGND VGND VPWR VPWR sky130_fd_sc_hd__fill_4
XFILLER_2_165 VPWR VGND VPWR VGND sky130_ef_sc_hd__decap_40_12
XFILLER_2_121 VPWR VGND VPWR VGND sky130_ef_sc_hd__decap_40_12
XFILLER_48_83 VGND VGND VPWR VPWR sky130_fd_sc_hd__fill_1
XFILLER_0_57 VPWR VGND VPWR VGND sky130_ef_sc_hd__decap_40_12
XFILLER_61_389 VGND VGND VPWR VPWR sky130_fd_sc_hd__fill_2
X_329_ _503_/Q _502_/Q _332_/S VGND VGND VPWR VPWR _330_/B sky130_fd_sc_hd__mux2_1
XFILLER_9_55 VGND VGND VPWR VPWR sky130_fd_sc_hd__fill_1
XFILLER_50_3 VPWR VGND VPWR VGND sky130_ef_sc_hd__decap_40_12
XFILLER_56_139 VGND VGND VPWR VPWR sky130_fd_sc_hd__fill_1
XFILLER_52_389 VPWR VGND VPWR VGND sky130_ef_sc_hd__decap_40_12
XFILLER_52_345 VPWR VGND VPWR VGND sky130_ef_sc_hd__decap_40_12
XFILLER_52_301 VGND VGND VPWR VPWR sky130_fd_sc_hd__fill_4
XFILLER_37_375 VGND VGND VPWR VPWR sky130_fd_sc_hd__fill_1
XFILLER_37_353 VGND VGND VPWR VPWR sky130_fd_sc_hd__fill_2
XFILLER_12_209 VPWR VGND VPWR VGND sky130_ef_sc_hd__decap_40_12
XFILLER_60_29 VPWR VGND VPWR VGND sky130_ef_sc_hd__decap_40_12
XFILLER_20_253 VGND VGND VPWR VPWR sky130_fd_sc_hd__fill_2
XFILLER_62_109 VPWR VGND VPWR VGND sky130_ef_sc_hd__decap_40_12
XFILLER_55_161 VGND VGND VPWR VPWR sky130_fd_sc_hd__fill_4
XFILLER_18_53 VPWR VGND VPWR VGND sky130_ef_sc_hd__decap_40_12
XFILLER_18_97 VPWR VGND VPWR VGND sky130_ef_sc_hd__decap_40_12
XFILLER_43_389 VGND VGND VPWR VPWR sky130_fd_sc_hd__fill_2
XFILLER_34_85 VPWR VGND VPWR VGND sky130_ef_sc_hd__decap_40_12
XFILLER_34_41 VPWR VGND VPWR VGND sky130_ef_sc_hd__decap_40_12
XFILLER_7_279 VGND VGND VPWR VPWR sky130_fd_sc_hd__fill_1
XFILLER_59_93 VPWR VGND VPWR VGND sky130_ef_sc_hd__decap_40_12
XFILLER_38_139 VGND VGND VPWR VPWR sky130_fd_sc_hd__fill_1
XFILLER_53_109 VGND VGND VPWR VPWR sky130_fd_sc_hd__fill_2
XFILLER_34_389 VGND VGND VPWR VPWR sky130_fd_sc_hd__fill_1
XFILLER_44_109 VPWR VGND VPWR VGND sky130_ef_sc_hd__decap_40_12
XTAP_TAPCELL_ROW_27_329 VGND VPWR sky130_fd_sc_hd__tapvpwrvgnd_1
XFILLER_52_197 VPWR VGND VPWR VGND sky130_ef_sc_hd__decap_40_12
XFILLER_52_153 VPWR VGND VPWR VGND sky130_ef_sc_hd__decap_40_12
XFILLER_40_304 VGND VGND VPWR VPWR sky130_fd_sc_hd__fill_4
XTAP_TAPCELL_ROW_35_384 VGND VPWR sky130_fd_sc_hd__tapvpwrvgnd_1
XTAP_TAPCELL_ROW_10_207 VGND VPWR sky130_fd_sc_hd__tapvpwrvgnd_1
XFILLER_4_249 VGND VGND VPWR VPWR sky130_fd_sc_hd__fill_2
XFILLER_20_65 VPWR VGND VPWR VGND sky130_ef_sc_hd__decap_40_12
Xhold30 _544_/Q VGND VGND VPWR VPWR _390_/B sky130_fd_sc_hd__dlygate4sd3_1
Xhold52 _509_/Q VGND VGND VPWR VPWR hold52/X sky130_fd_sc_hd__dlygate4sd3_1
Xhold74 _510_/Q VGND VGND VPWR VPWR hold74/X sky130_fd_sc_hd__dlygate4sd3_1
Xhold41 _478_/Y VGND VGND VPWR VPWR _562_/D sky130_fd_sc_hd__dlygate4sd3_1
Xhold63 _493_/Q VGND VGND VPWR VPWR _306_/A sky130_fd_sc_hd__dlygate4sd3_1
XFILLER_45_51 VGND VGND VPWR VPWR sky130_fd_sc_hd__fill_4
XFILLER_35_109 VGND VGND VPWR VPWR sky130_fd_sc_hd__fill_2
Xhold96 _564_/Q VGND VGND VPWR VPWR _277_/A sky130_fd_sc_hd__dlygate4sd3_1
XFILLER_16_301 VGND VGND VPWR VPWR sky130_fd_sc_hd__fill_4
XFILLER_16_345 VPWR VGND VPWR VGND sky130_ef_sc_hd__decap_40_12
XFILLER_16_389 VPWR VGND VPWR VGND sky130_ef_sc_hd__decap_40_12
Xhold85 _464_/Y VGND VGND VPWR VPWR _465_/B sky130_fd_sc_hd__dlygate4sd3_1
XFILLER_31_348 VGND VGND VPWR VPWR sky130_fd_sc_hd__fill_1
XFILLER_3_293 VPWR VGND VPWR VGND sky130_ef_sc_hd__decap_40_12
XFILLER_26_109 VPWR VGND VPWR VGND sky130_ef_sc_hd__decap_40_12
XFILLER_13_3 VPWR VGND VPWR VGND sky130_ef_sc_hd__decap_40_12
XFILLER_19_161 VGND VGND VPWR VPWR sky130_fd_sc_hd__fill_4
XFILLER_34_197 VGND VGND VPWR VPWR sky130_fd_sc_hd__fill_4
XFILLER_34_186 VGND VGND VPWR VPWR sky130_fd_sc_hd__fill_1
XFILLER_34_153 VPWR VGND VPWR VGND sky130_ef_sc_hd__decap_40_12
XTAP_TAPCELL_ROW_32_365 VGND VPWR sky130_fd_sc_hd__tapvpwrvgnd_1
XFILLER_57_223 VGND VGND VPWR VPWR sky130_fd_sc_hd__fill_1
XFILLER_17_109 VGND VGND VPWR VPWR sky130_fd_sc_hd__fill_2
XFILLER_13_337 VPWR VGND VPWR VGND sky130_ef_sc_hd__decap_40_12
XFILLER_21_370 VGND VGND VPWR VPWR sky130_fd_sc_hd__fill_2
Xoutput7 hold5/A VGND VGND VPWR VPWR led[4] sky130_fd_sc_hd__buf_2
XFILLER_63_237 VPWR VGND VPWR VGND sky130_ef_sc_hd__decap_40_12
XFILLER_56_83 VGND VGND VPWR VPWR sky130_fd_sc_hd__fill_1
XFILLER_48_289 VPWR VGND VPWR VGND sky130_ef_sc_hd__decap_40_12
XFILLER_48_245 VGND VGND VPWR VPWR sky130_fd_sc_hd__fill_4
XANTENNA__292__A1 _337_/B VGND VGND VPWR VPWR sky130_fd_sc_hd__diode_2
XFILLER_31_167 VGND VGND VPWR VPWR sky130_fd_sc_hd__fill_1
XFILLER_16_153 VPWR VGND VPWR VGND sky130_ef_sc_hd__decap_40_12
XFILLER_16_197 VPWR VGND VPWR VGND sky130_ef_sc_hd__decap_40_12
XFILLER_8_363 VGND VGND VPWR VPWR sky130_fd_sc_hd__fill_1
XFILLER_39_278 VGND VGND VPWR VPWR sky130_fd_sc_hd__fill_2
XTAP_TAPCELL_ROW_37_402 VGND VPWR sky130_fd_sc_hd__tapvpwrvgnd_1
XFILLER_10_307 VGND VGND VPWR VPWR sky130_fd_sc_hd__fill_1
XFILLER_22_189 VGND VGND VPWR VPWR sky130_fd_sc_hd__fill_4
X_500_ _516_/CLK _500_/D VGND VGND VPWR VPWR _500_/Q sky130_fd_sc_hd__dfxtp_1
XFILLER_53_281 VPWR VGND VPWR VGND sky130_ef_sc_hd__decap_40_12
XFILLER_45_237 VPWR VGND VPWR VGND sky130_ef_sc_hd__decap_40_12
XTAP_TAPCELL_ROW_43_438 VGND VPWR sky130_fd_sc_hd__tapvpwrvgnd_1
X_362_ _362_/A _376_/B VGND VGND VPWR VPWR _362_/X sky130_fd_sc_hd__or2_1
Xclkbuf_3_6__f_clk clkbuf_0_clk/X VGND VGND VPWR VPWR _523_/CLK sky130_fd_sc_hd__clkbuf_16
X_431_ _353_/A _337_/B _333_/A _337_/X VGND VGND VPWR VPWR _431_/X sky130_fd_sc_hd__a31o_1
XFILLER_26_97 VPWR VGND VPWR VGND sky130_ef_sc_hd__decap_40_12
XFILLER_26_53 VPWR VGND VPWR VGND sky130_ef_sc_hd__decap_40_12
XFILLER_9_105 VGND VGND VPWR VPWR sky130_fd_sc_hd__fill_4
XFILLER_13_167 VGND VGND VPWR VPWR sky130_fd_sc_hd__fill_1
XFILLER_42_85 VPWR VGND VPWR VGND sky130_ef_sc_hd__decap_40_12
XFILLER_42_41 VPWR VGND VPWR VGND sky130_ef_sc_hd__decap_40_12
X_293_ _485_/A _293_/B _293_/C VGND VGND VPWR VPWR _433_/A sky130_fd_sc_hd__nor3_1
XFILLER_5_333 VGND VGND VPWR VPWR sky130_fd_sc_hd__fill_2
XFILLER_9_149 VPWR VGND VPWR VGND sky130_ef_sc_hd__decap_40_12
XFILLER_3_57 VPWR VGND VPWR VGND sky130_ef_sc_hd__decap_40_12
XTAP_TAPCELL_ROW_8_193 VGND VPWR sky130_fd_sc_hd__tapvpwrvgnd_1
XFILLER_8_193 VGND VGND VPWR VPWR sky130_fd_sc_hd__fill_2
XFILLER_59_329 VGND VGND VPWR VPWR sky130_fd_sc_hd__fill_4
XFILLER_50_251 VGND VGND VPWR VPWR sky130_fd_sc_hd__fill_1
XFILLER_42_229 VGND VGND VPWR VPWR sky130_fd_sc_hd__fill_4
XFILLER_27_237 VGND VGND VPWR VPWR sky130_fd_sc_hd__fill_4
XPHY_EDGE_ROW_19_Left_84 VGND VGND VPWR VPWR sky130_fd_sc_hd__decap_3
XTAP_TAPCELL_ROW_40_419 VGND VPWR sky130_fd_sc_hd__tapvpwrvgnd_1
XFILLER_10_137 VGND VGND VPWR VPWR sky130_fd_sc_hd__fill_2
XFILLER_12_77 VGND VGND VPWR VPWR sky130_fd_sc_hd__fill_4
Xhold160 _417_/Y VGND VGND VPWR VPWR _535_/D sky130_fd_sc_hd__dlygate4sd3_1
XTAP_TAPCELL_ROW_56_530 VGND VPWR sky130_fd_sc_hd__tapvpwrvgnd_1
XTAP_TAPCELL_ROW_5_174 VGND VPWR sky130_fd_sc_hd__tapvpwrvgnd_1
XFILLER_53_51 VGND VGND VPWR VPWR sky130_fd_sc_hd__fill_4
X_345_ _390_/B _345_/B VGND VGND VPWR VPWR _345_/X sky130_fd_sc_hd__or2_1
X_414_ _421_/D _414_/B VGND VGND VPWR VPWR _414_/Y sky130_fd_sc_hd__nor2_1
X_276_ _472_/A _474_/C _466_/A _466_/C VGND VGND VPWR VPWR _278_/C sky130_fd_sc_hd__or4_1
XFILLER_49_373 VPWR VGND VPWR VGND sky130_ef_sc_hd__decap_40_12
XFILLER_1_391 VGND VGND VPWR VPWR sky130_fd_sc_hd__fill_1
XFILLER_64_365 VPWR VGND VPWR VGND sky130_ef_sc_hd__decap_40_12
XFILLER_64_321 VPWR VGND VPWR VGND sky130_ef_sc_hd__decap_40_12
XFILLER_17_281 VGND VGND VPWR VPWR sky130_fd_sc_hd__fill_4
XTAP_TAPCELL_ROW_19_276 VGND VPWR sky130_fd_sc_hd__tapvpwrvgnd_1
XFILLER_24_229 VGND VGND VPWR VPWR sky130_fd_sc_hd__fill_1
XTAP_TAPCELL_ROW_62_577 VGND VPWR sky130_fd_sc_hd__tapvpwrvgnd_1
XFILLER_32_251 VGND VGND VPWR VPWR sky130_fd_sc_hd__fill_1
XFILLER_59_137 VPWR VGND VPWR VGND sky130_ef_sc_hd__decap_40_12
XFILLER_58_29 VPWR VGND VPWR VGND sky130_ef_sc_hd__decap_40_12
XPHY_EDGE_ROW_12_Right_12 VGND VGND VPWR VPWR sky130_fd_sc_hd__decap_3
XTAP_TAPCELL_ROW_2_155 VGND VPWR sky130_fd_sc_hd__tapvpwrvgnd_1
XPHY_EDGE_ROW_21_Right_21 VGND VGND VPWR VPWR sky130_fd_sc_hd__decap_3
XTAP_TAPCELL_ROW_53_511 VGND VPWR sky130_fd_sc_hd__tapvpwrvgnd_1
XPHY_EDGE_ROW_4_Left_69 VGND VGND VPWR VPWR sky130_fd_sc_hd__decap_3
XPHY_EDGE_ROW_30_Right_30 VGND VGND VPWR VPWR sky130_fd_sc_hd__decap_3
XFILLER_2_177 VPWR VGND VPWR VGND sky130_ef_sc_hd__decap_40_12
XFILLER_2_133 VGND VGND VPWR VPWR sky130_fd_sc_hd__fill_4
XFILLER_64_83 VGND VGND VPWR VPWR sky130_fd_sc_hd__fill_1
XFILLER_61_335 VGND VGND VPWR VPWR sky130_fd_sc_hd__fill_1
XFILLER_46_365 VPWR VGND VPWR VGND sky130_ef_sc_hd__decap_40_12
XFILLER_46_321 VPWR VGND VPWR VGND sky130_ef_sc_hd__decap_40_12
XFILLER_0_69 VPWR VGND VPWR VGND sky130_ef_sc_hd__decap_40_12
X_259_ _537_/Q _535_/Q _534_/Q _536_/Q VGND VGND VPWR VPWR _260_/D sky130_fd_sc_hd__or4b_1
X_328_ _345_/B _337_/C hold68/X _273_/A VGND VGND VPWR VPWR _328_/X sky130_fd_sc_hd__o211a_1
XFILLER_14_251 VGND VGND VPWR VPWR sky130_fd_sc_hd__fill_1
XFILLER_43_3 VPWR VGND VPWR VGND sky130_ef_sc_hd__decap_40_12
XFILLER_49_181 VPWR VGND VPWR VGND sky130_ef_sc_hd__decap_40_12
XFILLER_64_195 VGND VGND VPWR VPWR sky130_fd_sc_hd__fill_1
XFILLER_52_357 VGND VGND VPWR VPWR sky130_fd_sc_hd__fill_4
XFILLER_20_221 VPWR VGND VPWR VGND sky130_ef_sc_hd__decap_40_12
XFILLER_18_65 VPWR VGND VPWR VGND sky130_ef_sc_hd__decap_40_12
XFILLER_50_41 VPWR VGND VPWR VGND sky130_ef_sc_hd__decap_40_12
XFILLER_34_97 VPWR VGND VPWR VGND sky130_ef_sc_hd__decap_40_12
XFILLER_34_53 VPWR VGND VPWR VGND sky130_ef_sc_hd__decap_40_12
XFILLER_7_225 VPWR VGND VPWR VGND sky130_ef_sc_hd__decap_40_12
XFILLER_11_221 VGND VGND VPWR VPWR sky130_fd_sc_hd__fill_2
XFILLER_50_85 VPWR VGND VPWR VGND sky130_ef_sc_hd__decap_40_12
XANTENNA__310__B1 _485_/A VGND VGND VPWR VPWR sky130_fd_sc_hd__diode_2
XFILLER_19_332 VGND VGND VPWR VPWR sky130_fd_sc_hd__fill_4
XFILLER_61_165 VGND VGND VPWR VPWR sky130_fd_sc_hd__fill_2
XFILLER_46_195 VGND VGND VPWR VPWR sky130_fd_sc_hd__fill_1
XFILLER_57_405 VGND VGND VPWR VPWR sky130_fd_sc_hd__fill_2
XFILLER_52_121 VPWR VGND VPWR VGND sky130_ef_sc_hd__decap_40_12
XFILLER_52_165 VPWR VGND VPWR VGND sky130_ef_sc_hd__decap_40_12
XTAP_TAPCELL_ROW_35_385 VGND VPWR sky130_fd_sc_hd__tapvpwrvgnd_1
XTAP_TAPCELL_ROW_10_208 VGND VPWR sky130_fd_sc_hd__tapvpwrvgnd_1
XFILLER_20_77 VGND VGND VPWR VPWR sky130_fd_sc_hd__fill_4
XFILLER_48_405 VGND VGND VPWR VPWR sky130_fd_sc_hd__fill_2
Xhold31 _518_/Q VGND VGND VPWR VPWR _368_/A sky130_fd_sc_hd__dlygate4sd3_1
Xhold53 _331_/X VGND VGND VPWR VPWR _502_/D sky130_fd_sc_hd__dlygate4sd3_1
Xhold75 _334_/X VGND VGND VPWR VPWR _503_/D sky130_fd_sc_hd__dlygate4sd3_1
Xhold64 _306_/X VGND VGND VPWR VPWR hold64/X sky130_fd_sc_hd__dlygate4sd3_1
XFILLER_29_20 VPWR VGND VPWR VGND sky130_ef_sc_hd__decap_40_12
Xhold20 _431_/X VGND VGND VPWR VPWR _546_/D sky130_fd_sc_hd__dlygate4sd3_1
Xhold97 _483_/X VGND VGND VPWR VPWR _564_/D sky130_fd_sc_hd__dlygate4sd3_1
Xhold42 _561_/Q VGND VGND VPWR VPWR _474_/A sky130_fd_sc_hd__dlygate4sd3_1
Xhold86 _465_/Y VGND VGND VPWR VPWR _557_/D sky130_fd_sc_hd__dlygate4sd3_1
XFILLER_43_165 VGND VGND VPWR VPWR sky130_fd_sc_hd__fill_2
XFILLER_16_357 VGND VGND VPWR VPWR sky130_fd_sc_hd__fill_4
XFILLER_61_51 VGND VGND VPWR VPWR sky130_fd_sc_hd__fill_4
XPHY_EDGE_ROW_7_Left_72 VGND VGND VPWR VPWR sky130_fd_sc_hd__decap_3
XFILLER_3_261 VPWR VGND VPWR VGND sky130_ef_sc_hd__decap_40_12
XFILLER_34_121 VPWR VGND VPWR VGND sky130_ef_sc_hd__decap_40_12
XFILLER_34_165 VGND VGND VPWR VPWR sky130_fd_sc_hd__fill_4
XTAP_TAPCELL_ROW_32_366 VGND VPWR sky130_fd_sc_hd__tapvpwrvgnd_1
XFILLER_22_316 VGND VGND VPWR VPWR sky130_fd_sc_hd__fill_1
XPHY_EDGE_ROW_6_Right_6 VGND VGND VPWR VPWR sky130_fd_sc_hd__decap_3
XANTENNA__286__C1 _485_/A VGND VGND VPWR VPWR sky130_fd_sc_hd__diode_2
XFILLER_57_279 VGND VGND VPWR VPWR sky130_fd_sc_hd__fill_1
XFILLER_25_165 VGND VGND VPWR VPWR sky130_fd_sc_hd__fill_2
XFILLER_13_305 VPWR VGND VPWR VGND sky130_ef_sc_hd__decap_40_12
XFILLER_13_349 VPWR VGND VPWR VGND sky130_ef_sc_hd__decap_40_12
XFILLER_15_55 VGND VGND VPWR VPWR sky130_fd_sc_hd__fill_1
XTAP_TAPCELL_ROW_23_300 VGND VPWR sky130_fd_sc_hd__tapvpwrvgnd_1
Xoutput8 hold3/A VGND VGND VPWR VPWR led[5] sky130_fd_sc_hd__buf_2
XPHY_EDGE_ROW_33_Left_98 VGND VGND VPWR VPWR sky130_fd_sc_hd__decap_3
Xoutput10 _497_/Q VGND VGND VPWR VPWR led[7] sky130_fd_sc_hd__buf_2
XFILLER_0_253 VPWR VGND VPWR VGND sky130_ef_sc_hd__decap_40_12
XFILLER_63_249 VPWR VGND VPWR VGND sky130_ef_sc_hd__decap_40_12
XFILLER_63_205 VPWR VGND VPWR VGND sky130_ef_sc_hd__decap_40_12
XFILLER_16_121 VPWR VGND VPWR VGND sky130_ef_sc_hd__decap_40_12
XPHY_EDGE_ROW_59_Right_59 VGND VGND VPWR VPWR sky130_fd_sc_hd__decap_3
XFILLER_31_179 VGND VGND VPWR VPWR sky130_fd_sc_hd__fill_1
XFILLER_31_113 VPWR VGND VPWR VGND sky130_ef_sc_hd__decap_40_12
XFILLER_16_165 VPWR VGND VPWR VGND sky130_ef_sc_hd__decap_40_12
XFILLER_54_249 VGND VGND VPWR VPWR sky130_fd_sc_hd__fill_2
XFILLER_45_249 VPWR VGND VPWR VGND sky130_ef_sc_hd__decap_40_12
XFILLER_45_205 VPWR VGND VPWR VGND sky130_ef_sc_hd__decap_40_12
XFILLER_53_293 VPWR VGND VPWR VGND sky130_ef_sc_hd__decap_40_12
XTAP_TAPCELL_ROW_43_439 VGND VPWR sky130_fd_sc_hd__tapvpwrvgnd_1
XFILLER_42_53 VPWR VGND VPWR VGND sky130_ef_sc_hd__decap_40_12
X_361_ _362_/A _356_/Y _374_/C _360_/X VGND VGND VPWR VPWR _361_/X sky130_fd_sc_hd__o211a_1
X_292_ _337_/B _283_/D _428_/A _390_/D VGND VGND VPWR VPWR _543_/D sky130_fd_sc_hd__a22o_1
X_430_ _485_/A _430_/B VGND VGND VPWR VPWR _545_/D sky130_fd_sc_hd__or2_1
XFILLER_26_65 VPWR VGND VPWR VGND sky130_ef_sc_hd__decap_40_12
XFILLER_13_113 VPWR VGND VPWR VGND sky130_ef_sc_hd__decap_40_12
XTAP_TAPCELL_ROW_51_494 VGND VPWR sky130_fd_sc_hd__tapvpwrvgnd_1
XFILLER_42_97 VPWR VGND VPWR VGND sky130_ef_sc_hd__decap_40_12
XFILLER_5_389 VGND VGND VPWR VPWR sky130_fd_sc_hd__fill_2
XFILLER_3_69 VPWR VGND VPWR VGND sky130_ef_sc_hd__decap_40_12
XTAP_TAPCELL_ROW_8_194 VGND VPWR sky130_fd_sc_hd__tapvpwrvgnd_1
XTAP_TAPCELL_ROW_59_550 VGND VPWR sky130_fd_sc_hd__tapvpwrvgnd_1
X_559_ _561_/CLK _559_/D VGND VGND VPWR VPWR _559_/Q sky130_fd_sc_hd__dfxtp_1
XFILLER_27_205 VGND VGND VPWR VPWR sky130_fd_sc_hd__fill_1
XFILLER_6_109 VPWR VGND VPWR VGND sky130_ef_sc_hd__decap_40_12
Xhold150 _533_/Q VGND VGND VPWR VPWR _412_/B sky130_fd_sc_hd__dlygate4sd3_1
Xhold161 _549_/Q VGND VGND VPWR VPWR _442_/A sky130_fd_sc_hd__dlygate4sd3_1
XFILLER_58_363 VGND VGND VPWR VPWR sky130_fd_sc_hd__fill_1
XTAP_TAPCELL_ROW_56_531 VGND VPWR sky130_fd_sc_hd__tapvpwrvgnd_1
X_413_ _412_/A _411_/A _428_/A VGND VGND VPWR VPWR _413_/Y sky130_fd_sc_hd__o21ai_1
XTAP_TAPCELL_ROW_5_175 VGND VPWR sky130_fd_sc_hd__tapvpwrvgnd_1
XFILLER_18_249 VGND VGND VPWR VPWR sky130_fd_sc_hd__fill_2
XFILLER_41_241 VGND VGND VPWR VPWR sky130_fd_sc_hd__fill_2
X_344_ _362_/A _374_/A _273_/A _343_/X VGND VGND VPWR VPWR _507_/D sky130_fd_sc_hd__o211a_1
X_275_ _466_/B _458_/A VGND VGND VPWR VPWR _278_/B sky130_fd_sc_hd__nand2_1
XFILLER_64_333 VGND VGND VPWR VPWR sky130_fd_sc_hd__fill_2
XFILLER_49_385 VGND VGND VPWR VPWR sky130_fd_sc_hd__fill_4
XFILLER_64_377 VPWR VGND VPWR VGND sky130_ef_sc_hd__decap_40_12
XPHY_EDGE_ROW_20_Left_85 VGND VGND VPWR VPWR sky130_fd_sc_hd__decap_3
XFILLER_59_149 VPWR VGND VPWR VGND sky130_ef_sc_hd__decap_40_12
XFILLER_59_105 VGND VGND VPWR VPWR sky130_fd_sc_hd__fill_4
XFILLER_55_333 VGND VGND VPWR VPWR sky130_fd_sc_hd__fill_2
XTAP_TAPCELL_ROW_53_512 VGND VPWR sky130_fd_sc_hd__tapvpwrvgnd_1
XTAP_TAPCELL_ROW_2_156 VGND VPWR sky130_fd_sc_hd__tapvpwrvgnd_1
XFILLER_23_55 VGND VGND VPWR VPWR sky130_fd_sc_hd__fill_1
XFILLER_23_285 VGND VGND VPWR VPWR sky130_fd_sc_hd__fill_2
XFILLER_23_296 VPWR VGND VPWR VGND sky130_ef_sc_hd__decap_40_12
XFILLER_3_3 VPWR VGND VPWR VGND sky130_ef_sc_hd__decap_40_12
XFILLER_58_193 VGND VGND VPWR VPWR sky130_fd_sc_hd__fill_2
XFILLER_48_85 VPWR VGND VPWR VGND sky130_ef_sc_hd__decap_40_12
XFILLER_48_41 VPWR VGND VPWR VGND sky130_ef_sc_hd__decap_40_12
XFILLER_46_333 VPWR VGND VPWR VGND sky130_ef_sc_hd__decap_40_12
XFILLER_2_189 VGND VGND VPWR VPWR sky130_fd_sc_hd__fill_4
XFILLER_0_15 VPWR VGND VPWR VGND sky130_ef_sc_hd__decap_40_12
XFILLER_46_377 VPWR VGND VPWR VGND sky130_ef_sc_hd__decap_40_12
X_258_ _533_/Q _531_/Q _528_/Q _532_/Q VGND VGND VPWR VPWR _260_/C sky130_fd_sc_hd__or4b_1
X_327_ _333_/A _327_/B VGND VGND VPWR VPWR _327_/X sky130_fd_sc_hd__or2_1
XFILLER_9_57 VPWR VGND VPWR VGND sky130_ef_sc_hd__decap_40_12
XFILLER_36_3 VPWR VGND VPWR VGND sky130_ef_sc_hd__decap_40_12
XFILLER_64_141 VPWR VGND VPWR VGND sky130_ef_sc_hd__decap_40_12
XFILLER_49_193 VPWR VGND VPWR VGND sky130_ef_sc_hd__decap_40_12
XFILLER_37_355 VGND VGND VPWR VPWR sky130_fd_sc_hd__fill_1
XFILLER_20_233 VPWR VGND VPWR VGND sky130_ef_sc_hd__decap_40_12
XFILLER_28_344 VGND VGND VPWR VPWR sky130_fd_sc_hd__fill_4
XFILLER_18_77 VGND VGND VPWR VPWR sky130_fd_sc_hd__fill_4
XFILLER_51_391 VGND VGND VPWR VPWR sky130_fd_sc_hd__fill_1
XFILLER_50_53 VPWR VGND VPWR VGND sky130_ef_sc_hd__decap_40_12
XFILLER_34_65 VPWR VGND VPWR VGND sky130_ef_sc_hd__decap_40_12
XFILLER_7_237 VPWR VGND VPWR VGND sky130_ef_sc_hd__decap_40_12
XFILLER_11_277 VGND VGND VPWR VPWR sky130_fd_sc_hd__fill_2
XTAP_TAPCELL_ROW_13_228 VGND VPWR sky130_fd_sc_hd__tapvpwrvgnd_1
XFILLER_59_51 VGND VGND VPWR VPWR sky130_fd_sc_hd__fill_4
XFILLER_50_97 VPWR VGND VPWR VGND sky130_ef_sc_hd__decap_40_12
XFILLER_46_141 VPWR VGND VPWR VGND sky130_ef_sc_hd__decap_40_12
XFILLER_61_111 VGND VGND VPWR VPWR sky130_fd_sc_hd__fill_1
XFILLER_52_177 VPWR VGND VPWR VGND sky130_ef_sc_hd__decap_40_12
XFILLER_52_133 VGND VGND VPWR VPWR sky130_fd_sc_hd__fill_4
XTAP_TAPCELL_ROW_35_386 VGND VPWR sky130_fd_sc_hd__tapvpwrvgnd_1
XFILLER_33_391 VGND VGND VPWR VPWR sky130_fd_sc_hd__fill_1
XTAP_TAPCELL_ROW_10_209 VGND VPWR sky130_fd_sc_hd__tapvpwrvgnd_1
XPHY_EDGE_ROW_42_Left_107 VGND VGND VPWR VPWR sky130_fd_sc_hd__decap_3
Xhold10 _313_/X VGND VGND VPWR VPWR _496_/D sky130_fd_sc_hd__dlygate4sd3_1
Xhold87 _527_/Q VGND VGND VPWR VPWR hold87/X sky130_fd_sc_hd__dlygate4sd3_1
Xhold32 _350_/X VGND VGND VPWR VPWR _510_/D sky130_fd_sc_hd__dlygate4sd3_1
Xhold54 _519_/Q VGND VGND VPWR VPWR hold54/X sky130_fd_sc_hd__dlygate4sd3_1
Xhold76 _528_/Q VGND VGND VPWR VPWR _252_/B sky130_fd_sc_hd__dlygate4sd3_1
Xhold21 _540_/Q VGND VGND VPWR VPWR hold21/X sky130_fd_sc_hd__dlygate4sd3_1
Xhold65 _307_/X VGND VGND VPWR VPWR _493_/D sky130_fd_sc_hd__dlygate4sd3_1
XFILLER_29_32 VPWR VGND VPWR VGND sky130_ef_sc_hd__decap_40_12
XFILLER_28_141 VPWR VGND VPWR VGND sky130_ef_sc_hd__decap_40_12
Xhold43 _475_/Y VGND VGND VPWR VPWR _476_/B sky130_fd_sc_hd__dlygate4sd3_1
Xhold98 _554_/Q VGND VGND VPWR VPWR _458_/B sky130_fd_sc_hd__dlygate4sd3_1
XPHY_EDGE_ROW_51_Left_116 VGND VGND VPWR VPWR sky130_fd_sc_hd__decap_3
XFILLER_43_111 VGND VGND VPWR VPWR sky130_fd_sc_hd__fill_1
XFILLER_31_317 VGND VGND VPWR VPWR sky130_fd_sc_hd__fill_2
XTAP_TAPCELL_ROW_26_320 VGND VPWR sky130_fd_sc_hd__tapvpwrvgnd_1
XPHY_EDGE_ROW_60_Left_125 VGND VGND VPWR VPWR sky130_fd_sc_hd__decap_3
XFILLER_3_273 VGND VGND VPWR VPWR sky130_fd_sc_hd__fill_4
XFILLER_34_133 VGND VGND VPWR VPWR sky130_fd_sc_hd__fill_4
XTAP_TAPCELL_ROW_32_367 VGND VPWR sky130_fd_sc_hd__tapvpwrvgnd_1
XFILLER_15_391 VGND VGND VPWR VPWR sky130_fd_sc_hd__fill_1
XFILLER_57_225 VPWR VGND VPWR VGND sky130_ef_sc_hd__decap_40_12
XFILLER_25_111 VGND VGND VPWR VPWR sky130_fd_sc_hd__fill_1
XFILLER_13_317 VPWR VGND VPWR VGND sky130_ef_sc_hd__decap_40_12
XTAP_TAPCELL_ROW_23_301 VGND VPWR sky130_fd_sc_hd__tapvpwrvgnd_1
XFILLER_40_169 VGND VGND VPWR VPWR sky130_fd_sc_hd__fill_1
XFILLER_31_55 VGND VGND VPWR VPWR sky130_fd_sc_hd__fill_1
XFILLER_21_372 VGND VGND VPWR VPWR sky130_fd_sc_hd__fill_1
XFILLER_21_383 VGND VGND VPWR VPWR sky130_fd_sc_hd__fill_1
Xoutput9 hold9/A VGND VGND VPWR VPWR led[6] sky130_fd_sc_hd__buf_2
Xoutput11 _565_/Q VGND VGND VPWR VPWR uart_txd sky130_fd_sc_hd__buf_2
XFILLER_0_221 VGND VGND VPWR VPWR sky130_fd_sc_hd__fill_2
XFILLER_0_265 VPWR VGND VPWR VGND sky130_ef_sc_hd__decap_40_12
XFILLER_63_217 VGND VGND VPWR VPWR sky130_fd_sc_hd__fill_4
XFILLER_56_85 VPWR VGND VPWR VGND sky130_ef_sc_hd__decap_40_12
XFILLER_56_41 VPWR VGND VPWR VGND sky130_ef_sc_hd__decap_40_12
XTAP_TAPCELL_ROW_46_459 VGND VPWR sky130_fd_sc_hd__tapvpwrvgnd_1
XANTENNA_clkbuf_3_1__f_clk_A clkbuf_0_clk/X VGND VGND VPWR VPWR sky130_fd_sc_hd__diode_2
XFILLER_16_133 VGND VGND VPWR VPWR sky130_fd_sc_hd__fill_4
XFILLER_31_169 VGND VGND VPWR VPWR sky130_fd_sc_hd__fill_4
XFILLER_31_125 VPWR VGND VPWR VGND sky130_ef_sc_hd__decap_40_12
XFILLER_8_321 VPWR VGND VPWR VGND sky130_ef_sc_hd__decap_40_12
XFILLER_12_361 VGND VGND VPWR VPWR sky130_fd_sc_hd__fill_2
XFILLER_16_177 VPWR VGND VPWR VGND sky130_ef_sc_hd__decap_40_12
XFILLER_8_365 VPWR VGND VPWR VGND sky130_ef_sc_hd__decap_40_12
XFILLER_50_401 VGND VGND VPWR VPWR sky130_fd_sc_hd__fill_4
XFILLER_10_309 VPWR VGND VPWR VGND sky130_ef_sc_hd__decap_40_12
XFILLER_60_209 VPWR VGND VPWR VGND sky130_ef_sc_hd__decap_40_12
XFILLER_45_217 VGND VGND VPWR VPWR sky130_fd_sc_hd__fill_4
XFILLER_53_261 VPWR VGND VPWR VGND sky130_ef_sc_hd__decap_40_12
XTAP_TAPCELL_ROW_51_495 VGND VPWR sky130_fd_sc_hd__tapvpwrvgnd_1
XFILLER_42_65 VPWR VGND VPWR VGND sky130_ef_sc_hd__decap_40_12
X_360_ _514_/Q _376_/B VGND VGND VPWR VPWR _360_/X sky130_fd_sc_hd__or2_1
X_291_ _485_/A _379_/D VGND VGND VPWR VPWR _428_/A sky130_fd_sc_hd__nor2_4
XFILLER_26_77 VGND VGND VPWR VPWR sky130_fd_sc_hd__fill_4
XFILLER_13_125 VPWR VGND VPWR VGND sky130_ef_sc_hd__decap_40_12
XFILLER_13_169 VPWR VGND VPWR VGND sky130_ef_sc_hd__decap_40_12
XFILLER_5_335 VGND VGND VPWR VPWR sky130_fd_sc_hd__fill_1
XTAP_TAPCELL_ROW_59_551 VGND VPWR sky130_fd_sc_hd__tapvpwrvgnd_1
XFILLER_36_206 VGND VGND VPWR VPWR sky130_fd_sc_hd__fill_4
XFILLER_3_15 VPWR VGND VPWR VGND sky130_ef_sc_hd__decap_40_12
XTAP_TAPCELL_ROW_8_195 VGND VPWR sky130_fd_sc_hd__tapvpwrvgnd_1
XFILLER_36_239 VPWR VGND VPWR VGND sky130_ef_sc_hd__decap_40_12
XFILLER_36_228 VGND VGND VPWR VPWR sky130_fd_sc_hd__fill_2
X_558_ _561_/CLK _558_/D VGND VGND VPWR VPWR _558_/Q sky130_fd_sc_hd__dfxtp_1
X_489_ _565_/CLK _489_/D VGND VGND VPWR VPWR _489_/Q sky130_fd_sc_hd__dfxtp_1
XFILLER_8_195 VGND VGND VPWR VPWR sky130_fd_sc_hd__fill_1
XFILLER_27_228 VGND VGND VPWR VPWR sky130_fd_sc_hd__fill_2
XFILLER_50_253 VPWR VGND VPWR VGND sky130_ef_sc_hd__decap_40_12
XFILLER_10_139 VGND VGND VPWR VPWR sky130_fd_sc_hd__fill_1
Xhold151 _410_/Y VGND VGND VPWR VPWR _411_/B sky130_fd_sc_hd__dlygate4sd3_1
Xhold140 _485_/X VGND VGND VPWR VPWR _565_/D sky130_fd_sc_hd__dlygate4sd3_1
XFILLER_2_305 VGND VGND VPWR VPWR sky130_fd_sc_hd__fill_2
Xhold162 _272_/X VGND VGND VPWR VPWR _293_/C sky130_fd_sc_hd__dlygate4sd3_1
XTAP_TAPCELL_ROW_5_176 VGND VPWR sky130_fd_sc_hd__tapvpwrvgnd_1
XTAP_TAPCELL_ROW_56_532 VGND VPWR sky130_fd_sc_hd__tapvpwrvgnd_1
X_412_ _412_/A _412_/B _532_/Q _412_/D VGND VGND VPWR VPWR _421_/D sky130_fd_sc_hd__and4_1
XFILLER_14_401 VGND VGND VPWR VPWR sky130_fd_sc_hd__fill_4
X_343_ _390_/B _343_/B VGND VGND VPWR VPWR _343_/X sky130_fd_sc_hd__or2_1
X_274_ _452_/A _452_/B _447_/A _458_/B VGND VGND VPWR VPWR _278_/A sky130_fd_sc_hd__or4b_1
XFILLER_5_165 VGND VGND VPWR VPWR sky130_fd_sc_hd__fill_2
XFILLER_1_393 VPWR VGND VPWR VGND sky130_ef_sc_hd__decap_40_12
XFILLER_24_209 VPWR VGND VPWR VGND sky130_ef_sc_hd__decap_40_12
XFILLER_64_389 VGND VGND VPWR VPWR sky130_fd_sc_hd__fill_2
XFILLER_32_253 VGND VGND VPWR VPWR sky130_fd_sc_hd__fill_1
XFILLER_17_261 VPWR VGND VPWR VGND sky130_ef_sc_hd__decap_40_12
XFILLER_20_404 VGND VGND VPWR VPWR sky130_fd_sc_hd__fill_2
XFILLER_55_389 VGND VGND VPWR VPWR sky130_fd_sc_hd__fill_2
XTAP_TAPCELL_ROW_53_513 VGND VPWR sky130_fd_sc_hd__tapvpwrvgnd_1
XTAP_TAPCELL_ROW_2_157 VGND VPWR sky130_fd_sc_hd__tapvpwrvgnd_1
XFILLER_48_97 VPWR VGND VPWR VGND sky130_ef_sc_hd__decap_40_12
XFILLER_48_53 VPWR VGND VPWR VGND sky130_ef_sc_hd__decap_40_12
XFILLER_46_345 VPWR VGND VPWR VGND sky130_ef_sc_hd__decap_40_12
XFILLER_0_27 VGND VGND VPWR VPWR sky130_fd_sc_hd__fill_1
XFILLER_64_85 VPWR VGND VPWR VGND sky130_ef_sc_hd__decap_40_12
XFILLER_64_41 VPWR VGND VPWR VGND sky130_ef_sc_hd__decap_40_12
XFILLER_61_337 VPWR VGND VPWR VGND sky130_ef_sc_hd__decap_40_12
XFILLER_46_389 VPWR VGND VPWR VGND sky130_ef_sc_hd__decap_40_12
X_326_ _502_/Q hold66/X _332_/S VGND VGND VPWR VPWR _326_/X sky130_fd_sc_hd__mux2_1
XFILLER_9_69 VPWR VGND VPWR VGND sky130_ef_sc_hd__decap_40_12
XFILLER_14_253 VPWR VGND VPWR VGND sky130_ef_sc_hd__decap_40_12
X_257_ _539_/Q _527_/Q _526_/Q _538_/Q VGND VGND VPWR VPWR _260_/B sky130_fd_sc_hd__or4b_1
XFILLER_56_109 VPWR VGND VPWR VGND sky130_ef_sc_hd__decap_40_12
XFILLER_64_197 VPWR VGND VPWR VGND sky130_ef_sc_hd__decap_40_12
XFILLER_64_153 VPWR VGND VPWR VGND sky130_ef_sc_hd__decap_40_12
XFILLER_49_161 VGND VGND VPWR VPWR sky130_fd_sc_hd__fill_4
XFILLER_20_245 VGND VGND VPWR VPWR sky130_fd_sc_hd__fill_2
XFILLER_47_109 VGND VGND VPWR VPWR sky130_fd_sc_hd__fill_2
XFILLER_43_337 VPWR VGND VPWR VGND sky130_ef_sc_hd__decap_40_12
XFILLER_34_77 VGND VGND VPWR VPWR sky130_fd_sc_hd__fill_4
XFILLER_11_223 VGND VGND VPWR VPWR sky130_fd_sc_hd__fill_1
XTAP_TAPCELL_ROW_13_229 VGND VPWR sky130_fd_sc_hd__tapvpwrvgnd_1
XFILLER_50_65 VPWR VGND VPWR VGND sky130_ef_sc_hd__decap_40_12
XFILLER_7_205 VPWR VGND VPWR VGND sky130_ef_sc_hd__decap_40_12
XFILLER_7_249 VPWR VGND VPWR VGND sky130_ef_sc_hd__decap_40_12
XTAP_TAPCELL_ROW_21_284 VGND VPWR sky130_fd_sc_hd__tapvpwrvgnd_1
XFILLER_38_109 VPWR VGND VPWR VGND sky130_ef_sc_hd__decap_40_12
XFILLER_46_197 VPWR VGND VPWR VGND sky130_ef_sc_hd__decap_40_12
XFILLER_46_153 VPWR VGND VPWR VGND sky130_ef_sc_hd__decap_40_12
XTAP_TAPCELL_ROW_29_340 VGND VPWR sky130_fd_sc_hd__tapvpwrvgnd_1
XFILLER_61_167 VGND VGND VPWR VPWR sky130_fd_sc_hd__fill_1
X_309_ hold5/X _283_/X _308_/X VGND VGND VPWR VPWR hold6/A sky130_fd_sc_hd__a21o_1
XFILLER_29_109 VGND VGND VPWR VPWR sky130_fd_sc_hd__fill_2
XFILLER_52_189 VGND VGND VPWR VPWR sky130_fd_sc_hd__fill_4
XFILLER_37_186 VPWR VGND VPWR VGND sky130_ef_sc_hd__decap_40_12
XFILLER_37_164 VGND VGND VPWR VPWR sky130_fd_sc_hd__fill_4
XTAP_TAPCELL_ROW_35_387 VGND VPWR sky130_fd_sc_hd__tapvpwrvgnd_1
XFILLER_1_81 VPWR VGND VPWR VGND sky130_ef_sc_hd__decap_40_12
Xhold11 _513_/Q VGND VGND VPWR VPWR _357_/A sky130_fd_sc_hd__dlygate4sd3_1
Xhold22 _271_/X VGND VGND VPWR VPWR _541_/D sky130_fd_sc_hd__dlygate4sd3_1
XFILLER_29_44 VPWR VGND VPWR VGND sky130_ef_sc_hd__decap_40_12
Xhold88 _393_/Y VGND VGND VPWR VPWR _394_/B sky130_fd_sc_hd__dlygate4sd3_1
Xhold33 _517_/Q VGND VGND VPWR VPWR _366_/A sky130_fd_sc_hd__dlygate4sd3_1
Xhold66 _501_/Q VGND VGND VPWR VPWR hold66/X sky130_fd_sc_hd__dlygate4sd3_1
Xhold55 _352_/X VGND VGND VPWR VPWR _511_/D sky130_fd_sc_hd__dlygate4sd3_1
Xhold77 _396_/Y VGND VGND VPWR VPWR _528_/D sky130_fd_sc_hd__dlygate4sd3_1
Xhold44 _476_/Y VGND VGND VPWR VPWR _561_/D sky130_fd_sc_hd__dlygate4sd3_1
XFILLER_28_153 VPWR VGND VPWR VGND sky130_ef_sc_hd__decap_40_12
XTAP_TAPCELL_ROW_26_321 VGND VPWR sky130_fd_sc_hd__tapvpwrvgnd_1
Xhold99 _455_/Y VGND VGND VPWR VPWR hold99/X sky130_fd_sc_hd__dlygate4sd3_1
XFILLER_43_167 VGND VGND VPWR VPWR sky130_fd_sc_hd__fill_1
XANTENNA__247__A _337_/B VGND VGND VPWR VPWR sky130_fd_sc_hd__diode_2
XFILLER_6_15 VPWR VGND VPWR VGND sky130_ef_sc_hd__decap_40_12
XFILLER_30_340 VGND VGND VPWR VPWR sky130_fd_sc_hd__fill_1
XFILLER_57_237 VPWR VGND VPWR VGND sky130_ef_sc_hd__decap_40_12
XFILLER_40_137 VGND VGND VPWR VPWR sky130_fd_sc_hd__fill_2
XFILLER_25_167 VGND VGND VPWR VPWR sky130_fd_sc_hd__fill_1
XFILLER_13_329 VGND VGND VPWR VPWR sky130_fd_sc_hd__fill_4
XFILLER_15_57 VPWR VGND VPWR VGND sky130_ef_sc_hd__decap_40_12
XTAP_TAPCELL_ROW_23_302 VGND VPWR sky130_fd_sc_hd__tapvpwrvgnd_1
XFILLER_0_277 VGND VGND VPWR VPWR sky130_fd_sc_hd__fill_2
XFILLER_56_97 VPWR VGND VPWR VGND sky130_ef_sc_hd__decap_40_12
XFILLER_56_53 VPWR VGND VPWR VGND sky130_ef_sc_hd__decap_40_12
XFILLER_16_189 VGND VGND VPWR VPWR sky130_fd_sc_hd__fill_4
XFILLER_31_137 VPWR VGND VPWR VGND sky130_ef_sc_hd__decap_40_12
XFILLER_8_333 VPWR VGND VPWR VGND sky130_ef_sc_hd__decap_40_12
XFILLER_8_377 VPWR VGND VPWR VGND sky130_ef_sc_hd__decap_40_12
XFILLER_47_281 VPWR VGND VPWR VGND sky130_ef_sc_hd__decap_40_12
XFILLER_39_237 VGND VGND VPWR VPWR sky130_fd_sc_hd__fill_1
XFILLER_11_3 VPWR VGND VPWR VGND sky130_ef_sc_hd__decap_40_12
XFILLER_62_251 VGND VGND VPWR VPWR sky130_fd_sc_hd__fill_1
XFILLER_22_137 VGND VGND VPWR VPWR sky130_fd_sc_hd__fill_2
XFILLER_53_273 VGND VGND VPWR VPWR sky130_fd_sc_hd__fill_4
XFILLER_41_402 VGND VGND VPWR VPWR sky130_fd_sc_hd__fill_1
XTAP_TAPCELL_ROW_51_496 VGND VPWR sky130_fd_sc_hd__tapvpwrvgnd_1
XFILLER_42_77 VGND VGND VPWR VPWR sky130_fd_sc_hd__fill_4
X_290_ _390_/D _337_/B _379_/D _289_/X VGND VGND VPWR VPWR _542_/D sky130_fd_sc_hd__a31o_1
XFILLER_13_137 VPWR VGND VPWR VGND sky130_ef_sc_hd__decap_40_12
XFILLER_21_181 VPWR VGND VPWR VGND sky130_ef_sc_hd__decap_40_12
XFILLER_3_27 VPWR VGND VPWR VGND sky130_ef_sc_hd__decap_40_12
XTAP_TAPCELL_ROW_59_552 VGND VPWR sky130_fd_sc_hd__tapvpwrvgnd_1
XTAP_TAPCELL_ROW_8_196 VGND VPWR sky130_fd_sc_hd__tapvpwrvgnd_1
XFILLER_44_240 VPWR VGND VPWR VGND sky130_ef_sc_hd__decap_40_12
X_488_ _564_/CLK _488_/D VGND VGND VPWR VPWR _488_/Q sky130_fd_sc_hd__dfxtp_1
X_557_ _561_/CLK _557_/D VGND VGND VPWR VPWR _557_/Q sky130_fd_sc_hd__dfxtp_1
XFILLER_59_3 VPWR VGND VPWR VGND sky130_ef_sc_hd__decap_40_12
XFILLER_8_141 VPWR VGND VPWR VGND sky130_ef_sc_hd__decap_40_12
XFILLER_27_218 VGND VGND VPWR VPWR sky130_fd_sc_hd__fill_4
XFILLER_50_265 VPWR VGND VPWR VGND sky130_ef_sc_hd__decap_40_12
XFILLER_50_221 VPWR VGND VPWR VGND sky130_ef_sc_hd__decap_40_12
Xhold141 _539_/Q VGND VGND VPWR VPWR _427_/A sky130_fd_sc_hd__dlygate4sd3_1
Xhold152 _411_/Y VGND VGND VPWR VPWR _533_/D sky130_fd_sc_hd__dlygate4sd3_1
Xhold163 _279_/X VGND VGND VPWR VPWR _487_/D sky130_fd_sc_hd__dlygate4sd3_1
Xhold130 _553_/Q VGND VGND VPWR VPWR _452_/A sky130_fd_sc_hd__dlygate4sd3_1
XFILLER_58_365 VPWR VGND VPWR VGND sky130_ef_sc_hd__decap_40_12
XFILLER_58_321 VPWR VGND VPWR VGND sky130_ef_sc_hd__decap_40_12
XFILLER_37_55 VGND VGND VPWR VPWR sky130_fd_sc_hd__fill_1
XTAP_TAPCELL_ROW_5_177 VGND VPWR sky130_fd_sc_hd__tapvpwrvgnd_1
XTAP_TAPCELL_ROW_56_533 VGND VPWR sky130_fd_sc_hd__tapvpwrvgnd_1
X_342_ hold57/X _374_/A _273_/A _341_/X VGND VGND VPWR VPWR _506_/D sky130_fd_sc_hd__o211a_1
X_411_ _411_/A _411_/B VGND VGND VPWR VPWR _411_/Y sky130_fd_sc_hd__nor2_1
XFILLER_26_240 VGND VGND VPWR VPWR sky130_fd_sc_hd__fill_2
X_273_ _273_/A _434_/A _293_/C VGND VGND VPWR VPWR _273_/X sky130_fd_sc_hd__and3_1
XFILLER_5_111 VGND VGND VPWR VPWR sky130_fd_sc_hd__fill_1
XFILLER_1_361 VPWR VGND VPWR VGND sky130_ef_sc_hd__decap_40_12
XFILLER_64_335 VGND VGND VPWR VPWR sky130_fd_sc_hd__fill_1
XFILLER_17_273 VGND VGND VPWR VPWR sky130_fd_sc_hd__fill_4
XFILLER_4_81 VGND VGND VPWR VPWR sky130_fd_sc_hd__fill_2
XFILLER_55_335 VGND VGND VPWR VPWR sky130_fd_sc_hd__fill_1
XTAP_TAPCELL_ROW_53_514 VGND VPWR sky130_fd_sc_hd__tapvpwrvgnd_1
XFILLER_11_405 VGND VGND VPWR VPWR sky130_fd_sc_hd__fill_2
XFILLER_23_221 VGND VGND VPWR VPWR sky130_fd_sc_hd__fill_2
XFILLER_23_57 VPWR VGND VPWR VGND sky130_ef_sc_hd__decap_40_12
XFILLER_23_287 VGND VGND VPWR VPWR sky130_fd_sc_hd__fill_1
XFILLER_64_53 VGND VGND VPWR VPWR sky130_fd_sc_hd__fill_2
XFILLER_61_305 VPWR VGND VPWR VGND sky130_ef_sc_hd__decap_40_12
XFILLER_58_195 VGND VGND VPWR VPWR sky130_fd_sc_hd__fill_1
XFILLER_48_65 VPWR VGND VPWR VGND sky130_ef_sc_hd__decap_40_12
XFILLER_46_357 VGND VGND VPWR VPWR sky130_fd_sc_hd__fill_4
XFILLER_64_97 VPWR VGND VPWR VGND sky130_ef_sc_hd__decap_40_12
XFILLER_61_349 VPWR VGND VPWR VGND sky130_ef_sc_hd__decap_40_12
X_325_ _343_/B _337_/C hold72/X _273_/A VGND VGND VPWR VPWR _325_/X sky130_fd_sc_hd__o211a_1
XFILLER_9_15 VPWR VGND VPWR VGND sky130_ef_sc_hd__decap_40_12
XFILLER_14_221 VPWR VGND VPWR VGND sky130_ef_sc_hd__decap_40_12
XFILLER_14_265 VPWR VGND VPWR VGND sky130_ef_sc_hd__decap_40_12
XTAP_TAPCELL_ROW_16_249 VGND VPWR sky130_fd_sc_hd__tapvpwrvgnd_1
X_256_ _530_/Q _256_/B VGND VGND VPWR VPWR _260_/A sky130_fd_sc_hd__nand2_1
XFILLER_64_165 VGND VGND VPWR VPWR sky130_fd_sc_hd__fill_2
XFILLER_52_305 VGND VGND VPWR VPWR sky130_fd_sc_hd__fill_2
XFILLER_55_165 VGND VGND VPWR VPWR sky130_fd_sc_hd__fill_2
XFILLER_51_393 VPWR VGND VPWR VGND sky130_ef_sc_hd__decap_40_12
XFILLER_43_349 VPWR VGND VPWR VGND sky130_ef_sc_hd__decap_40_12
XFILLER_50_77 VGND VGND VPWR VPWR sky130_fd_sc_hd__fill_4
Xclkload0 _545_/CLK VGND VGND VPWR VPWR clkload0/Y sky130_fd_sc_hd__inv_6
XFILLER_7_217 VGND VGND VPWR VPWR sky130_fd_sc_hd__fill_4
XFILLER_11_279 VGND VGND VPWR VPWR sky130_fd_sc_hd__fill_1
XTAP_TAPCELL_ROW_21_285 VGND VPWR sky130_fd_sc_hd__tapvpwrvgnd_1
XFILLER_61_113 VPWR VGND VPWR VGND sky130_ef_sc_hd__decap_40_12
XFILLER_46_165 VPWR VGND VPWR VGND sky130_ef_sc_hd__decap_40_12
XFILLER_46_121 VPWR VGND VPWR VGND sky130_ef_sc_hd__decap_40_12
XFILLER_34_327 VGND VGND VPWR VPWR sky130_fd_sc_hd__fill_4
XTAP_TAPCELL_ROW_29_341 VGND VPWR sky130_fd_sc_hd__tapvpwrvgnd_1
X_308_ _509_/Q _306_/B _485_/A VGND VGND VPWR VPWR _308_/X sky130_fd_sc_hd__a21o_1
XFILLER_41_3 VPWR VGND VPWR VGND sky130_ef_sc_hd__decap_40_12
XFILLER_37_198 VGND VGND VPWR VPWR sky130_fd_sc_hd__fill_4
XTAP_TAPCELL_ROW_35_388 VGND VPWR sky130_fd_sc_hd__tapvpwrvgnd_1
XANTENNA__337__B _337_/B VGND VGND VPWR VPWR sky130_fd_sc_hd__diode_2
XFILLER_1_93 VPWR VGND VPWR VGND sky130_ef_sc_hd__decap_40_12
XFILLER_4_209 VPWR VGND VPWR VGND sky130_ef_sc_hd__decap_40_12
Xhold12 _340_/X VGND VGND VPWR VPWR _505_/D sky130_fd_sc_hd__dlygate4sd3_1
Xhold45 _515_/Q VGND VGND VPWR VPWR _362_/A sky130_fd_sc_hd__dlygate4sd3_1
Xhold56 _542_/Q VGND VGND VPWR VPWR _390_/C sky130_fd_sc_hd__dlygate4sd3_1
Xhold34 _348_/X VGND VGND VPWR VPWR _509_/D sky130_fd_sc_hd__dlygate4sd3_1
Xhold23 _558_/Q VGND VGND VPWR VPWR _466_/A sky130_fd_sc_hd__dlygate4sd3_1
XFILLER_45_55 VGND VGND VPWR VPWR sky130_fd_sc_hd__fill_1
XFILLER_43_113 VPWR VGND VPWR VGND sky130_ef_sc_hd__decap_40_12
Xhold89 _394_/Y VGND VGND VPWR VPWR _527_/D sky130_fd_sc_hd__dlygate4sd3_1
Xhold67 _326_/X VGND VGND VPWR VPWR _327_/B sky130_fd_sc_hd__dlygate4sd3_1
Xhold78 _491_/Q VGND VGND VPWR VPWR _302_/A sky130_fd_sc_hd__dlygate4sd3_1
XFILLER_28_165 VPWR VGND VPWR VGND sky130_ef_sc_hd__decap_40_12
XFILLER_28_121 VPWR VGND VPWR VGND sky130_ef_sc_hd__decap_40_12
XTAP_TAPCELL_ROW_26_322 VGND VPWR sky130_fd_sc_hd__tapvpwrvgnd_1
XFILLER_16_305 VGND VGND VPWR VPWR sky130_fd_sc_hd__fill_2
XFILLER_6_27 VGND VGND VPWR VPWR sky130_fd_sc_hd__fill_1
XFILLER_19_165 VGND VGND VPWR VPWR sky130_fd_sc_hd__fill_2
XFILLER_30_330 VGND VGND VPWR VPWR sky130_fd_sc_hd__fill_1
XFILLER_15_393 VPWR VGND VPWR VGND sky130_ef_sc_hd__decap_40_12
XANTENNA_clkbuf_0_clk_A clk VGND VGND VPWR VPWR sky130_fd_sc_hd__diode_2
XFILLER_30_363 VGND VGND VPWR VPWR sky130_fd_sc_hd__fill_1
XFILLER_57_205 VPWR VGND VPWR VGND sky130_ef_sc_hd__decap_40_12
XANTENNA__286__A2 _283_/X VGND VGND VPWR VPWR sky130_fd_sc_hd__diode_2
XFILLER_57_249 VPWR VGND VPWR VGND sky130_ef_sc_hd__decap_40_12
XFILLER_25_113 VPWR VGND VPWR VGND sky130_ef_sc_hd__decap_40_12
XFILLER_33_190 VPWR VGND VPWR VGND sky130_ef_sc_hd__decap_40_12
XFILLER_15_69 VPWR VGND VPWR VGND sky130_ef_sc_hd__decap_40_12
XTAP_TAPCELL_ROW_23_303 VGND VPWR sky130_fd_sc_hd__tapvpwrvgnd_1
XFILLER_31_57 VPWR VGND VPWR VGND sky130_ef_sc_hd__decap_40_12
XFILLER_56_65 VPWR VGND VPWR VGND sky130_ef_sc_hd__decap_40_12
XFILLER_48_249 VGND VGND VPWR VPWR sky130_fd_sc_hd__fill_2
XFILLER_0_223 VGND VGND VPWR VPWR sky130_fd_sc_hd__fill_1
XFILLER_31_149 VPWR VGND VPWR VGND sky130_ef_sc_hd__decap_40_12
XFILLER_31_105 VGND VGND VPWR VPWR sky130_fd_sc_hd__fill_4
XPHY_EDGE_ROW_19_Right_19 VGND VGND VPWR VPWR sky130_fd_sc_hd__decap_3
Xclkbuf_3_1__f_clk clkbuf_0_clk/X VGND VGND VPWR VPWR _561_/CLK sky130_fd_sc_hd__clkbuf_16
XFILLER_8_301 VGND VGND VPWR VPWR sky130_fd_sc_hd__fill_4
XFILLER_8_345 VPWR VGND VPWR VGND sky130_ef_sc_hd__decap_40_12
XFILLER_8_389 VPWR VGND VPWR VGND sky130_ef_sc_hd__decap_40_12
XFILLER_12_363 VGND VGND VPWR VPWR sky130_fd_sc_hd__fill_1
XPHY_EDGE_ROW_28_Right_28 VGND VGND VPWR VPWR sky130_fd_sc_hd__decap_3
XFILLER_47_293 VPWR VGND VPWR VGND sky130_ef_sc_hd__decap_40_12
XPHY_EDGE_ROW_37_Right_37 VGND VGND VPWR VPWR sky130_fd_sc_hd__decap_3
XPHY_EDGE_ROW_46_Right_46 VGND VGND VPWR VPWR sky130_fd_sc_hd__decap_3
XFILLER_7_81 VPWR VGND VPWR VGND sky130_ef_sc_hd__decap_40_12
XPHY_EDGE_ROW_55_Right_55 VGND VGND VPWR VPWR sky130_fd_sc_hd__decap_3
XANTENNA__431__A2 _337_/B VGND VGND VPWR VPWR sky130_fd_sc_hd__diode_2
XFILLER_13_105 VGND VGND VPWR VPWR sky130_fd_sc_hd__fill_4
XFILLER_13_149 VPWR VGND VPWR VGND sky130_ef_sc_hd__decap_40_12
XPHY_EDGE_ROW_64_Right_64 VGND VGND VPWR VPWR sky130_fd_sc_hd__decap_3
XTAP_TAPCELL_ROW_51_497 VGND VPWR sky130_fd_sc_hd__tapvpwrvgnd_1
XPHY_EDGE_ROW_39_Left_104 VGND VGND VPWR VPWR sky130_fd_sc_hd__decap_3
XFILLER_5_337 VPWR VGND VPWR VGND sky130_ef_sc_hd__decap_40_12
XFILLER_9_109 VGND VGND VPWR VPWR sky130_fd_sc_hd__fill_2
XFILLER_21_193 VPWR VGND VPWR VGND sky130_ef_sc_hd__decap_40_12
XFILLER_3_39 VPWR VGND VPWR VGND sky130_ef_sc_hd__decap_40_12
XTAP_TAPCELL_ROW_59_553 VGND VPWR sky130_fd_sc_hd__tapvpwrvgnd_1
XPHY_EDGE_ROW_48_Left_113 VGND VGND VPWR VPWR sky130_fd_sc_hd__decap_3
XFILLER_29_293 VGND VGND VPWR VPWR sky130_fd_sc_hd__fill_1
XTAP_TAPCELL_ROW_8_197 VGND VPWR sky130_fd_sc_hd__tapvpwrvgnd_1
XTAP_TAPCELL_ROW_42_431 VGND VPWR sky130_fd_sc_hd__tapvpwrvgnd_1
X_487_ _565_/CLK _487_/D VGND VGND VPWR VPWR _487_/Q sky130_fd_sc_hd__dfxtp_2
X_556_ _561_/CLK _556_/D VGND VGND VPWR VPWR _556_/Q sky130_fd_sc_hd__dfxtp_1
XPHY_EDGE_ROW_57_Left_122 VGND VGND VPWR VPWR sky130_fd_sc_hd__decap_3
XFILLER_8_153 VPWR VGND VPWR VGND sky130_ef_sc_hd__decap_40_12
XFILLER_8_197 VPWR VGND VPWR VGND sky130_ef_sc_hd__decap_40_12
XFILLER_12_193 VGND VGND VPWR VPWR sky130_fd_sc_hd__fill_2
XFILLER_50_233 VPWR VGND VPWR VGND sky130_ef_sc_hd__decap_40_12
XFILLER_50_277 VPWR VGND VPWR VGND sky130_ef_sc_hd__decap_40_12
XFILLER_12_15 VPWR VGND VPWR VGND sky130_ef_sc_hd__decap_40_12
Xhold142 _427_/Y VGND VGND VPWR VPWR _428_/C sky130_fd_sc_hd__dlygate4sd3_1
Xhold120 _413_/Y VGND VGND VPWR VPWR _414_/B sky130_fd_sc_hd__dlygate4sd3_1
Xhold164 _532_/Q VGND VGND VPWR VPWR _406_/A sky130_fd_sc_hd__dlygate4sd3_1
XFILLER_2_307 VGND VGND VPWR VPWR sky130_fd_sc_hd__fill_1
Xhold131 _451_/X VGND VGND VPWR VPWR _454_/C sky130_fd_sc_hd__dlygate4sd3_1
Xhold153 _547_/Q VGND VGND VPWR VPWR _436_/A sky130_fd_sc_hd__dlygate4sd3_1
XFILLER_58_377 VPWR VGND VPWR VGND sky130_ef_sc_hd__decap_40_12
XFILLER_58_333 VPWR VGND VPWR VGND sky130_ef_sc_hd__decap_40_12
XTAP_TAPCELL_ROW_56_534 VGND VPWR sky130_fd_sc_hd__tapvpwrvgnd_1
XTAP_TAPCELL_ROW_5_178 VGND VPWR sky130_fd_sc_hd__tapvpwrvgnd_1
XFILLER_53_55 VGND VGND VPWR VPWR sky130_fd_sc_hd__fill_1
XFILLER_41_288 VGND VGND VPWR VPWR sky130_fd_sc_hd__fill_1
XFILLER_41_211 VPWR VGND VPWR VGND sky130_ef_sc_hd__decap_40_12
X_341_ _390_/B _341_/B VGND VGND VPWR VPWR _341_/X sky130_fd_sc_hd__or2_1
X_410_ _412_/B _408_/A _428_/A VGND VGND VPWR VPWR _410_/Y sky130_fd_sc_hd__o21ai_1
X_272_ _442_/A _548_/Q _436_/A _444_/A VGND VGND VPWR VPWR _272_/X sky130_fd_sc_hd__or4b_1
XFILLER_5_167 VGND VGND VPWR VPWR sky130_fd_sc_hd__fill_1
XFILLER_49_333 VGND VGND VPWR VPWR sky130_fd_sc_hd__fill_2
XFILLER_1_373 VPWR VGND VPWR VGND sky130_ef_sc_hd__decap_40_12
XFILLER_17_285 VGND VGND VPWR VPWR sky130_fd_sc_hd__fill_2
X_539_ _539_/CLK _539_/D VGND VGND VPWR VPWR _539_/Q sky130_fd_sc_hd__dfxtp_1
XFILLER_20_406 VGND VGND VPWR VPWR sky130_fd_sc_hd__fill_1
XFILLER_63_391 VGND VGND VPWR VPWR sky130_fd_sc_hd__fill_1
XTAP_TAPCELL_ROW_61_570 VGND VPWR sky130_fd_sc_hd__tapvpwrvgnd_1
XFILLER_23_277 VGND VGND VPWR VPWR sky130_fd_sc_hd__fill_2
XFILLER_23_69 VPWR VGND VPWR VGND sky130_ef_sc_hd__decap_40_12
XFILLER_58_141 VPWR VGND VPWR VGND sky130_ef_sc_hd__decap_40_12
XFILLER_2_137 VGND VGND VPWR VPWR sky130_fd_sc_hd__fill_2
XFILLER_61_317 VPWR VGND VPWR VGND sky130_ef_sc_hd__decap_40_12
XFILLER_48_77 VGND VGND VPWR VPWR sky130_fd_sc_hd__fill_4
XFILLER_0_29 VPWR VGND VPWR VGND sky130_ef_sc_hd__decap_40_12
X_255_ _268_/A _255_/B _255_/C _255_/D VGND VGND VPWR VPWR _255_/X sky130_fd_sc_hd__or4_2
X_324_ _333_/A _324_/B VGND VGND VPWR VPWR _324_/X sky130_fd_sc_hd__or2_1
XFILLER_9_27 VPWR VGND VPWR VGND sky130_ef_sc_hd__decap_40_12
XFILLER_14_233 VPWR VGND VPWR VGND sky130_ef_sc_hd__decap_40_12
XFILLER_14_277 VPWR VGND VPWR VGND sky130_ef_sc_hd__decap_40_12
XPHY_EDGE_ROW_24_Left_89 VGND VGND VPWR VPWR sky130_fd_sc_hd__decap_3
XFILLER_64_111 VGND VGND VPWR VPWR sky130_fd_sc_hd__fill_1
XFILLER_1_181 VPWR VGND VPWR VGND sky130_ef_sc_hd__decap_40_12
XFILLER_60_361 VGND VGND VPWR VPWR sky130_fd_sc_hd__fill_2
XFILLER_45_391 VGND VGND VPWR VPWR sky130_fd_sc_hd__fill_1
XFILLER_9_281 VPWR VGND VPWR VGND sky130_ef_sc_hd__decap_40_12
XFILLER_20_247 VGND VGND VPWR VPWR sky130_fd_sc_hd__fill_1
XFILLER_55_111 VGND VGND VPWR VPWR sky130_fd_sc_hd__fill_1
XFILLER_28_336 VGND VGND VPWR VPWR sky130_fd_sc_hd__fill_1
XFILLER_51_361 VPWR VGND VPWR VGND sky130_ef_sc_hd__decap_40_12
Xclkload1 _561_/CLK VGND VGND VPWR VPWR clkload1/Y sky130_fd_sc_hd__clkinvlp_4
XFILLER_11_225 VPWR VGND VPWR VGND sky130_ef_sc_hd__decap_40_12
XFILLER_1_3 VPWR VGND VPWR VGND sky130_ef_sc_hd__decap_40_12
XTAP_TAPCELL_ROW_21_286 VGND VPWR sky130_fd_sc_hd__tapvpwrvgnd_1
XFILLER_46_133 VGND VGND VPWR VPWR sky130_fd_sc_hd__fill_4
XFILLER_61_169 VPWR VGND VPWR VGND sky130_ef_sc_hd__decap_40_12
XFILLER_61_125 VPWR VGND VPWR VGND sky130_ef_sc_hd__decap_40_12
XFILLER_46_177 VPWR VGND VPWR VGND sky130_ef_sc_hd__decap_40_12
XTAP_TAPCELL_ROW_29_342 VGND VPWR sky130_fd_sc_hd__tapvpwrvgnd_1
XFILLER_19_369 VGND VGND VPWR VPWR sky130_fd_sc_hd__fill_1
XANTENNA__283__X _283_/X VGND VGND VPWR VPWR sky130_fd_sc_hd__diode_2
X_307_ _345_/B _283_/X hold64/X _273_/A VGND VGND VPWR VPWR _307_/X sky130_fd_sc_hd__o211a_1
XFILLER_6_251 VGND VGND VPWR VPWR sky130_fd_sc_hd__fill_1
XFILLER_34_3 VPWR VGND VPWR VGND sky130_ef_sc_hd__decap_40_12
XFILLER_37_111 VGND VGND VPWR VPWR sky130_fd_sc_hd__fill_1
XFILLER_20_15 VPWR VGND VPWR VGND sky130_ef_sc_hd__decap_40_12
Xhold57 _514_/Q VGND VGND VPWR VPWR hold57/X sky130_fd_sc_hd__dlygate4sd3_1
Xhold46 _361_/X VGND VGND VPWR VPWR _514_/D sky130_fd_sc_hd__dlygate4sd3_1
Xhold13 _525_/Q VGND VGND VPWR VPWR _387_/A sky130_fd_sc_hd__dlygate4sd3_1
Xhold68 _327_/X VGND VGND VPWR VPWR hold68/X sky130_fd_sc_hd__dlygate4sd3_1
Xhold35 _541_/Q VGND VGND VPWR VPWR _358_/A sky130_fd_sc_hd__dlygate4sd3_1
Xhold79 _302_/X VGND VGND VPWR VPWR hold79/X sky130_fd_sc_hd__dlygate4sd3_1
XFILLER_29_57 VPWR VGND VPWR VGND sky130_ef_sc_hd__decap_40_12
XFILLER_0_405 VGND VGND VPWR VPWR sky130_fd_sc_hd__fill_2
Xhold24 _467_/Y VGND VGND VPWR VPWR _468_/B sky130_fd_sc_hd__dlygate4sd3_1
XFILLER_43_169 VPWR VGND VPWR VGND sky130_ef_sc_hd__decap_40_12
XFILLER_43_125 VPWR VGND VPWR VGND sky130_ef_sc_hd__decap_40_12
XFILLER_28_177 VGND VGND VPWR VPWR sky130_fd_sc_hd__fill_8
XFILLER_28_133 VGND VGND VPWR VPWR sky130_fd_sc_hd__fill_4
XTAP_TAPCELL_ROW_26_323 VGND VPWR sky130_fd_sc_hd__tapvpwrvgnd_1
XFILLER_61_55 VGND VGND VPWR VPWR sky130_fd_sc_hd__fill_1
XFILLER_3_221 VGND VGND VPWR VPWR sky130_fd_sc_hd__fill_2
XFILLER_10_81 VGND VGND VPWR VPWR sky130_fd_sc_hd__fill_2
XFILLER_62_401 VGND VGND VPWR VPWR sky130_fd_sc_hd__fill_4
XFILLER_19_111 VGND VGND VPWR VPWR sky130_fd_sc_hd__fill_1
XFILLER_15_361 VPWR VGND VPWR VGND sky130_ef_sc_hd__decap_40_12
XFILLER_57_217 VGND VGND VPWR VPWR sky130_fd_sc_hd__fill_4
XPHY_EDGE_ROW_27_Left_92 VGND VGND VPWR VPWR sky130_fd_sc_hd__decap_3
XFILLER_25_169 VPWR VGND VPWR VGND sky130_ef_sc_hd__decap_40_12
XFILLER_25_125 VPWR VGND VPWR VGND sky130_ef_sc_hd__decap_40_12
XPHY_EDGE_ROW_11_Left_76 VGND VGND VPWR VPWR sky130_fd_sc_hd__decap_3
XFILLER_15_15 VPWR VGND VPWR VGND sky130_ef_sc_hd__decap_40_12
XTAP_TAPCELL_ROW_23_304 VGND VPWR sky130_fd_sc_hd__tapvpwrvgnd_1
XFILLER_40_139 VGND VGND VPWR VPWR sky130_fd_sc_hd__fill_1
XFILLER_31_69 VPWR VGND VPWR VGND sky130_ef_sc_hd__decap_40_12
XFILLER_56_77 VGND VGND VPWR VPWR sky130_fd_sc_hd__fill_4
XFILLER_44_401 VGND VGND VPWR VPWR sky130_fd_sc_hd__fill_4
XFILLER_0_279 VGND VGND VPWR VPWR sky130_fd_sc_hd__fill_1
XFILLER_8_357 VGND VGND VPWR VPWR sky130_fd_sc_hd__fill_4
XFILLER_62_253 VPWR VGND VPWR VGND sky130_ef_sc_hd__decap_40_12
XFILLER_54_209 VPWR VGND VPWR VGND sky130_ef_sc_hd__decap_40_12
XFILLER_47_261 VPWR VGND VPWR VGND sky130_ef_sc_hd__decap_40_12
XFILLER_30_194 VGND VGND VPWR VPWR sky130_fd_sc_hd__fill_2
XFILLER_22_139 VGND VGND VPWR VPWR sky130_fd_sc_hd__fill_1
XFILLER_7_93 VPWR VGND VPWR VGND sky130_ef_sc_hd__decap_40_12
XTAP_TAPCELL_ROW_51_498 VGND VPWR sky130_fd_sc_hd__tapvpwrvgnd_1
XFILLER_5_349 VPWR VGND VPWR VGND sky130_ef_sc_hd__decap_40_12
XFILLER_5_305 VPWR VGND VPWR VGND sky130_ef_sc_hd__decap_40_12
XFILLER_21_161 VGND VGND VPWR VPWR sky130_fd_sc_hd__fill_4
XTAP_TAPCELL_ROW_8_198 VGND VPWR sky130_fd_sc_hd__tapvpwrvgnd_1
XTAP_TAPCELL_ROW_59_554 VGND VPWR sky130_fd_sc_hd__tapvpwrvgnd_1
XFILLER_44_253 VPWR VGND VPWR VGND sky130_ef_sc_hd__decap_40_12
X_555_ _564_/CLK _555_/D VGND VGND VPWR VPWR _555_/Q sky130_fd_sc_hd__dfxtp_1
XTAP_TAPCELL_ROW_42_432 VGND VPWR sky130_fd_sc_hd__tapvpwrvgnd_1
X_486_ _565_/CLK _486_/D VGND VGND VPWR VPWR _486_/Q sky130_fd_sc_hd__dfxtp_1
XFILLER_8_121 VPWR VGND VPWR VGND sky130_ef_sc_hd__decap_40_12
XFILLER_8_165 VPWR VGND VPWR VGND sky130_ef_sc_hd__decap_40_12
XFILLER_50_245 VGND VGND VPWR VPWR sky130_fd_sc_hd__fill_4
XFILLER_50_289 VPWR VGND VPWR VGND sky130_ef_sc_hd__decap_40_12
Xhold110 _287_/X VGND VGND VPWR VPWR _289_/C sky130_fd_sc_hd__dlygate4sd3_1
XFILLER_10_109 VPWR VGND VPWR VGND sky130_ef_sc_hd__decap_40_12
XFILLER_12_27 VGND VGND VPWR VPWR sky130_fd_sc_hd__fill_1
XFILLER_58_301 VGND VGND VPWR VPWR sky130_fd_sc_hd__fill_4
Xhold143 _428_/X VGND VGND VPWR VPWR _539_/D sky130_fd_sc_hd__dlygate4sd3_1
Xhold121 _414_/Y VGND VGND VPWR VPWR _534_/D sky130_fd_sc_hd__dlygate4sd3_1
Xhold165 _407_/Y VGND VGND VPWR VPWR _408_/B sky130_fd_sc_hd__dlygate4sd3_1
Xhold132 _454_/X VGND VGND VPWR VPWR _553_/D sky130_fd_sc_hd__dlygate4sd3_1
Xhold154 _435_/X VGND VGND VPWR VPWR _437_/C sky130_fd_sc_hd__dlygate4sd3_1
XFILLER_58_389 VPWR VGND VPWR VGND sky130_ef_sc_hd__decap_40_12
XFILLER_58_345 VPWR VGND VPWR VGND sky130_ef_sc_hd__decap_40_12
XTAP_TAPCELL_ROW_56_535 VGND VPWR sky130_fd_sc_hd__tapvpwrvgnd_1
XFILLER_37_57 VPWR VGND VPWR VGND sky130_ef_sc_hd__decap_40_12
XFILLER_26_220 VPWR VGND VPWR VGND sky130_ef_sc_hd__decap_40_12
XFILLER_18_209 VPWR VGND VPWR VGND sky130_ef_sc_hd__decap_40_12
XTAP_TAPCELL_ROW_64_590 VGND VPWR sky130_fd_sc_hd__tapvpwrvgnd_1
XFILLER_41_223 VGND VGND VPWR VPWR sky130_fd_sc_hd__fill_1
X_340_ _357_/A _374_/A _273_/A _339_/X VGND VGND VPWR VPWR _340_/X sky130_fd_sc_hd__o211a_1
X_271_ hold21/X _541_/Q _379_/D _544_/Q _485_/A VGND VGND VPWR VPWR _271_/X sky130_fd_sc_hd__a221o_1
XFILLER_5_113 VPWR VGND VPWR VGND sky130_ef_sc_hd__decap_40_12
XFILLER_49_389 VGND VGND VPWR VPWR sky130_fd_sc_hd__fill_2
XFILLER_1_385 VGND VGND VPWR VPWR sky130_fd_sc_hd__fill_4
XFILLER_64_337 VPWR VGND VPWR VGND sky130_ef_sc_hd__decap_40_12
X_538_ _539_/CLK _538_/D VGND VGND VPWR VPWR _538_/Q sky130_fd_sc_hd__dfxtp_1
XFILLER_32_212 VPWR VGND VPWR VGND sky130_ef_sc_hd__decap_40_12
XFILLER_64_3 VPWR VGND VPWR VGND sky130_ef_sc_hd__decap_40_12
X_469_ _474_/C _474_/D _481_/A VGND VGND VPWR VPWR _469_/Y sky130_fd_sc_hd__o21ai_1
XFILLER_59_109 VGND VGND VPWR VPWR sky130_fd_sc_hd__fill_2
XFILLER_4_83 VGND VGND VPWR VPWR sky130_fd_sc_hd__fill_1
XFILLER_55_337 VPWR VGND VPWR VGND sky130_ef_sc_hd__decap_40_12
XFILLER_23_15 VPWR VGND VPWR VGND sky130_ef_sc_hd__decap_40_12
XFILLER_23_223 VGND VGND VPWR VPWR sky130_fd_sc_hd__fill_1
XFILLER_58_153 VPWR VGND VPWR VGND sky130_ef_sc_hd__decap_40_12
XFILLER_64_55 VGND VGND VPWR VPWR sky130_fd_sc_hd__fill_1
XFILLER_61_329 VGND VGND VPWR VPWR sky130_fd_sc_hd__fill_4
XFILLER_58_197 VPWR VGND VPWR VGND sky130_ef_sc_hd__decap_40_12
XFILLER_14_245 VGND VGND VPWR VPWR sky130_fd_sc_hd__fill_4
X_254_ _534_/Q _533_/Q _532_/Q _535_/Q VGND VGND VPWR VPWR _255_/D sky130_fd_sc_hd__or4b_1
X_323_ hold66/X hold70/X _332_/S VGND VGND VPWR VPWR _323_/X sky130_fd_sc_hd__mux2_1
XFILLER_9_39 VPWR VGND VPWR VGND sky130_ef_sc_hd__decap_40_12
XFILLER_13_81 VPWR VGND VPWR VGND sky130_ef_sc_hd__decap_40_12
XFILLER_14_289 VPWR VGND VPWR VGND sky130_ef_sc_hd__decap_40_12
XANTENNA__313__A2 _283_/X VGND VGND VPWR VPWR sky130_fd_sc_hd__diode_2
XFILLER_64_167 VGND VGND VPWR VPWR sky130_fd_sc_hd__fill_1
XFILLER_52_307 VGND VGND VPWR VPWR sky130_fd_sc_hd__fill_1
XFILLER_1_193 VPWR VGND VPWR VGND sky130_ef_sc_hd__decap_40_12
XFILLER_9_293 VPWR VGND VPWR VGND sky130_ef_sc_hd__decap_40_12
XFILLER_18_15 VPWR VGND VPWR VGND sky130_ef_sc_hd__decap_40_12
XFILLER_55_167 VGND VGND VPWR VPWR sky130_fd_sc_hd__fill_1
XFILLER_51_373 VPWR VGND VPWR VGND sky130_ef_sc_hd__decap_40_12
Xclkload2 _539_/CLK VGND VGND VPWR VPWR clkload2/Y sky130_fd_sc_hd__inv_6
XFILLER_11_237 VPWR VGND VPWR VGND sky130_ef_sc_hd__decap_40_12
XTAP_TAPCELL_ROW_21_287 VGND VPWR sky130_fd_sc_hd__tapvpwrvgnd_1
XFILLER_59_55 VGND VGND VPWR VPWR sky130_fd_sc_hd__fill_1
XTAP_TAPCELL_ROW_29_343 VGND VPWR sky130_fd_sc_hd__tapvpwrvgnd_1
XFILLER_19_315 VGND VGND VPWR VPWR sky130_fd_sc_hd__fill_1
XFILLER_19_337 VPWR VGND VPWR VGND sky130_ef_sc_hd__decap_40_12
XFILLER_61_137 VPWR VGND VPWR VGND sky130_ef_sc_hd__decap_40_12
XFILLER_46_189 VGND VGND VPWR VPWR sky130_fd_sc_hd__fill_4
XFILLER_42_362 VGND VGND VPWR VPWR sky130_fd_sc_hd__fill_2
X_306_ _306_/A _306_/B VGND VGND VPWR VPWR _306_/X sky130_fd_sc_hd__or2_1
XANTENNA_clkbuf_3_4__f_clk_A clkbuf_0_clk/X VGND VGND VPWR VPWR sky130_fd_sc_hd__diode_2
XTAP_TAPCELL_ROW_12_221 VGND VPWR sky130_fd_sc_hd__tapvpwrvgnd_1
XFILLER_27_3 VPWR VGND VPWR VGND sky130_ef_sc_hd__decap_40_12
XANTENNA__298__A1 _337_/B VGND VGND VPWR VPWR sky130_fd_sc_hd__diode_2
XFILLER_52_137 VGND VGND VPWR VPWR sky130_fd_sc_hd__fill_2
XFILLER_1_51 VGND VGND VPWR VPWR sky130_fd_sc_hd__fill_4
XFILLER_20_27 VGND VGND VPWR VPWR sky130_fd_sc_hd__fill_1
Xhold47 _507_/Q VGND VGND VPWR VPWR _343_/B sky130_fd_sc_hd__dlygate4sd3_1
Xhold58 _508_/Q VGND VGND VPWR VPWR _345_/B sky130_fd_sc_hd__dlygate4sd3_1
Xhold36 _367_/X VGND VGND VPWR VPWR _517_/D sky130_fd_sc_hd__dlygate4sd3_1
Xhold14 _373_/X VGND VGND VPWR VPWR _520_/D sky130_fd_sc_hd__dlygate4sd3_1
Xhold69 _328_/X VGND VGND VPWR VPWR _501_/D sky130_fd_sc_hd__dlygate4sd3_1
XFILLER_29_69 VPWR VGND VPWR VGND sky130_ef_sc_hd__decap_40_12
Xhold25 _468_/Y VGND VGND VPWR VPWR _558_/D sky130_fd_sc_hd__dlygate4sd3_1
XFILLER_51_181 VPWR VGND VPWR VGND sky130_ef_sc_hd__decap_40_12
XFILLER_45_57 VPWR VGND VPWR VGND sky130_ef_sc_hd__decap_40_12
XFILLER_43_137 VPWR VGND VPWR VGND sky130_ef_sc_hd__decap_40_12
XTAP_TAPCELL_ROW_26_324 VGND VPWR sky130_fd_sc_hd__tapvpwrvgnd_1
XFILLER_16_307 VGND VGND VPWR VPWR sky130_fd_sc_hd__fill_1
XFILLER_6_29 VPWR VGND VPWR VGND sky130_ef_sc_hd__decap_40_12
XFILLER_3_277 VGND VGND VPWR VPWR sky130_fd_sc_hd__fill_2
XFILLER_59_281 VPWR VGND VPWR VGND sky130_ef_sc_hd__decap_40_12
XFILLER_34_137 VGND VGND VPWR VPWR sky130_fd_sc_hd__fill_2
XFILLER_19_167 VGND VGND VPWR VPWR sky130_fd_sc_hd__fill_1
XFILLER_15_373 VPWR VGND VPWR VGND sky130_ef_sc_hd__decap_40_12
XFILLER_25_137 VPWR VGND VPWR VGND sky130_ef_sc_hd__decap_40_12
XFILLER_15_27 VPWR VGND VPWR VGND sky130_ef_sc_hd__decap_40_12
XTAP_TAPCELL_ROW_31_360 VGND VPWR sky130_fd_sc_hd__tapvpwrvgnd_1
XFILLER_31_15 VPWR VGND VPWR VGND sky130_ef_sc_hd__decap_40_12
XPHY_EDGE_ROW_1_Right_1 VGND VGND VPWR VPWR sky130_fd_sc_hd__decap_3
XFILLER_0_225 VPWR VGND VPWR VGND sky130_ef_sc_hd__decap_40_12
XFILLER_56_251 VGND VGND VPWR VPWR sky130_fd_sc_hd__fill_1
XFILLER_16_137 VGND VGND VPWR VPWR sky130_fd_sc_hd__fill_2
XFILLER_12_321 VPWR VGND VPWR VGND sky130_ef_sc_hd__decap_40_12
XFILLER_12_365 VPWR VGND VPWR VGND sky130_ef_sc_hd__decap_40_12
XFILLER_21_81 VPWR VGND VPWR VGND sky130_ef_sc_hd__decap_40_12
XFILLER_62_265 VPWR VGND VPWR VGND sky130_ef_sc_hd__decap_40_12
XFILLER_62_221 VPWR VGND VPWR VGND sky130_ef_sc_hd__decap_40_12
XFILLER_50_405 VGND VGND VPWR VPWR sky130_fd_sc_hd__fill_2
XFILLER_47_273 VGND VGND VPWR VPWR sky130_fd_sc_hd__fill_4
XTAP_TAPCELL_ROW_45_452 VGND VPWR sky130_fd_sc_hd__tapvpwrvgnd_1
XFILLER_15_181 VPWR VGND VPWR VGND sky130_ef_sc_hd__decap_40_12
XFILLER_7_391 VGND VGND VPWR VPWR sky130_fd_sc_hd__fill_1
XFILLER_53_221 VGND VGND VPWR VPWR sky130_fd_sc_hd__fill_2
XFILLER_38_273 VGND VGND VPWR VPWR sky130_fd_sc_hd__fill_4
XFILLER_26_15 VPWR VGND VPWR VGND sky130_ef_sc_hd__decap_40_12
XTAP_TAPCELL_ROW_51_499 VGND VPWR sky130_fd_sc_hd__tapvpwrvgnd_1
XANTENNA__352__B1 _337_/B VGND VGND VPWR VPWR sky130_fd_sc_hd__diode_2
XFILLER_5_317 VPWR VGND VPWR VGND sky130_ef_sc_hd__decap_40_12
XTAP_TAPCELL_ROW_59_555 VGND VPWR sky130_fd_sc_hd__tapvpwrvgnd_1
XTAP_TAPCELL_ROW_8_199 VGND VPWR sky130_fd_sc_hd__tapvpwrvgnd_1
XFILLER_44_265 VGND VGND VPWR VPWR sky130_fd_sc_hd__fill_4
X_485_ _485_/A _486_/Q _485_/C VGND VGND VPWR VPWR _485_/X sky130_fd_sc_hd__or3_1
X_554_ _564_/CLK _554_/D VGND VGND VPWR VPWR _554_/Q sky130_fd_sc_hd__dfxtp_1
XTAP_TAPCELL_ROW_42_433 VGND VPWR sky130_fd_sc_hd__tapvpwrvgnd_1
XFILLER_8_133 VGND VGND VPWR VPWR sky130_fd_sc_hd__fill_4
XFILLER_8_177 VPWR VGND VPWR VGND sky130_ef_sc_hd__decap_40_12
XFILLER_12_195 VGND VGND VPWR VPWR sky130_fd_sc_hd__fill_1
XFILLER_16_81 VGND VGND VPWR VPWR sky130_fd_sc_hd__fill_2
XFILLER_4_361 VGND VGND VPWR VPWR sky130_fd_sc_hd__fill_2
XFILLER_35_243 VGND VGND VPWR VPWR sky130_fd_sc_hd__fill_2
Xhold122 _521_/Q VGND VGND VPWR VPWR _379_/B sky130_fd_sc_hd__dlygate4sd3_1
Xhold133 _536_/Q VGND VGND VPWR VPWR _421_/B sky130_fd_sc_hd__dlygate4sd3_1
Xhold144 _563_/Q VGND VGND VPWR VPWR _480_/A sky130_fd_sc_hd__dlygate4sd3_1
XFILLER_2_309 VPWR VGND VPWR VGND sky130_ef_sc_hd__decap_40_12
Xhold100 _456_/X VGND VGND VPWR VPWR _554_/D sky130_fd_sc_hd__dlygate4sd3_1
Xhold111 _489_/Q VGND VGND VPWR VPWR _434_/B sky130_fd_sc_hd__dlygate4sd3_1
XFILLER_58_357 VGND VGND VPWR VPWR sky130_fd_sc_hd__fill_4
Xhold155 _437_/X VGND VGND VPWR VPWR _547_/D sky130_fd_sc_hd__dlygate4sd3_1
Xhold166 _551_/Q VGND VGND VPWR VPWR _447_/A sky130_fd_sc_hd__dlygate4sd3_1
XFILLER_37_69 VPWR VGND VPWR VGND sky130_ef_sc_hd__decap_40_12
XFILLER_26_276 VGND VGND VPWR VPWR sky130_fd_sc_hd__fill_2
XFILLER_26_232 VGND VGND VPWR VPWR sky130_fd_sc_hd__fill_8
XFILLER_14_405 VGND VGND VPWR VPWR sky130_fd_sc_hd__fill_2
XTAP_TAPCELL_ROW_64_591 VGND VPWR sky130_fd_sc_hd__tapvpwrvgnd_1
XFILLER_53_57 VPWR VGND VPWR VGND sky130_ef_sc_hd__decap_40_12
X_270_ _390_/B _379_/D VGND VGND VPWR VPWR _283_/C sky130_fd_sc_hd__nand2_1
XFILLER_5_169 VPWR VGND VPWR VGND sky130_ef_sc_hd__decap_40_12
XFILLER_5_125 VPWR VGND VPWR VGND sky130_ef_sc_hd__decap_40_12
XFILLER_64_349 VPWR VGND VPWR VGND sky130_ef_sc_hd__decap_40_12
XFILLER_64_305 VGND VGND VPWR VPWR sky130_fd_sc_hd__fill_2
XFILLER_49_335 VGND VGND VPWR VPWR sky130_fd_sc_hd__fill_1
XFILLER_17_221 VGND VGND VPWR VPWR sky130_fd_sc_hd__fill_2
X_537_ _539_/CLK _537_/D VGND VGND VPWR VPWR _537_/Q sky130_fd_sc_hd__dfxtp_1
XFILLER_32_224 VGND VGND VPWR VPWR sky130_fd_sc_hd__fill_2
XFILLER_17_287 VGND VGND VPWR VPWR sky130_fd_sc_hd__fill_1
X_468_ _474_/D _468_/B VGND VGND VPWR VPWR _468_/Y sky130_fd_sc_hd__nor2_1
XFILLER_57_3 VPWR VGND VPWR VGND sky130_ef_sc_hd__decap_40_12
X_399_ _398_/X _428_/A _399_/C VGND VGND VPWR VPWR _529_/D sky130_fd_sc_hd__and3b_1
XFILLER_55_349 VPWR VGND VPWR VGND sky130_ef_sc_hd__decap_40_12
XFILLER_55_305 VPWR VGND VPWR VGND sky130_ef_sc_hd__decap_40_12
XFILLER_63_393 VPWR VGND VPWR VGND sky130_ef_sc_hd__decap_40_12
XFILLER_23_27 VPWR VGND VPWR VGND sky130_ef_sc_hd__decap_40_12
XFILLER_23_279 VGND VGND VPWR VPWR sky130_fd_sc_hd__fill_1
XFILLER_2_139 VGND VGND VPWR VPWR sky130_fd_sc_hd__fill_1
XFILLER_58_165 VPWR VGND VPWR VGND sky130_ef_sc_hd__decap_40_12
XFILLER_58_121 VPWR VGND VPWR VGND sky130_ef_sc_hd__decap_40_12
XFILLER_39_390 VGND VGND VPWR VPWR sky130_fd_sc_hd__fill_2
X_322_ _341_/B _337_/C hold94/X _273_/A VGND VGND VPWR VPWR _322_/X sky130_fd_sc_hd__o211a_1
XTAP_TAPCELL_ROW_1_150 VGND VPWR sky130_fd_sc_hd__tapvpwrvgnd_1
X_253_ _530_/Q _256_/B _528_/Q _531_/Q VGND VGND VPWR VPWR _253_/Y sky130_fd_sc_hd__nand4b_1
XFILLER_6_401 VGND VGND VPWR VPWR sky130_fd_sc_hd__fill_4
XFILLER_13_93 VPWR VGND VPWR VGND sky130_ef_sc_hd__decap_40_12
XFILLER_22_290 VGND VGND VPWR VPWR sky130_fd_sc_hd__fill_1
XFILLER_1_161 VGND VGND VPWR VPWR sky130_fd_sc_hd__fill_4
XFILLER_64_113 VPWR VGND VPWR VGND sky130_ef_sc_hd__decap_40_12
XFILLER_49_165 VGND VGND VPWR VPWR sky130_fd_sc_hd__fill_2
Xclkbuf_3_7__f_clk clkbuf_0_clk/X VGND VGND VPWR VPWR _516_/CLK sky130_fd_sc_hd__clkbuf_16
XFILLER_60_363 VGND VGND VPWR VPWR sky130_fd_sc_hd__fill_1
XFILLER_45_393 VPWR VGND VPWR VGND sky130_ef_sc_hd__decap_40_12
XFILLER_9_261 VPWR VGND VPWR VGND sky130_ef_sc_hd__decap_40_12
XFILLER_55_113 VPWR VGND VPWR VGND sky130_ef_sc_hd__decap_40_12
XFILLER_18_27 VGND VGND VPWR VPWR sky130_fd_sc_hd__fill_1
XFILLER_43_308 VPWR VGND VPWR VGND sky130_ef_sc_hd__decap_40_12
XFILLER_36_360 VGND VGND VPWR VPWR sky130_fd_sc_hd__fill_2
XFILLER_34_15 VPWR VGND VPWR VGND sky130_ef_sc_hd__decap_40_12
XFILLER_11_205 VPWR VGND VPWR VGND sky130_ef_sc_hd__decap_40_12
XFILLER_51_385 VGND VGND VPWR VPWR sky130_fd_sc_hd__fill_4
Xclkload3 _544_/CLK VGND VGND VPWR VPWR clkload3/Y sky130_fd_sc_hd__inv_4
XFILLER_11_249 VPWR VGND VPWR VGND sky130_ef_sc_hd__decap_40_12
XTAP_TAPCELL_ROW_21_288 VGND VPWR sky130_fd_sc_hd__tapvpwrvgnd_1
XFILLER_61_105 VGND VGND VPWR VPWR sky130_fd_sc_hd__fill_4
XTAP_TAPCELL_ROW_29_344 VGND VPWR sky130_fd_sc_hd__tapvpwrvgnd_1
XFILLER_19_349 VPWR VGND VPWR VGND sky130_ef_sc_hd__decap_40_12
XFILLER_61_149 VPWR VGND VPWR VGND sky130_ef_sc_hd__decap_40_12
X_305_ _343_/B _283_/X hold60/X _273_/A VGND VGND VPWR VPWR _305_/X sky130_fd_sc_hd__o211a_1
XTAP_TAPCELL_ROW_12_222 VGND VPWR sky130_fd_sc_hd__tapvpwrvgnd_1
XANTENNA__293__A _485_/A VGND VGND VPWR VPWR sky130_fd_sc_hd__diode_2
XFILLER_24_81 VGND VGND VPWR VPWR sky130_fd_sc_hd__fill_2
XFILLER_6_253 VPWR VGND VPWR VGND sky130_ef_sc_hd__decap_40_12
XFILLER_37_113 VPWR VGND VPWR VGND sky130_ef_sc_hd__decap_40_12
XFILLER_60_193 VGND VGND VPWR VPWR sky130_fd_sc_hd__fill_2
XFILLER_43_105 VGND VGND VPWR VPWR sky130_fd_sc_hd__fill_4
Xhold59 _492_/Q VGND VGND VPWR VPWR _304_/A sky130_fd_sc_hd__dlygate4sd3_1
Xhold26 _520_/Q VGND VGND VPWR VPWR hold26/X sky130_fd_sc_hd__dlygate4sd3_1
Xhold37 _516_/Q VGND VGND VPWR VPWR _364_/A sky130_fd_sc_hd__dlygate4sd3_1
Xhold48 _529_/Q VGND VGND VPWR VPWR _256_/B sky130_fd_sc_hd__dlygate4sd3_1
Xhold15 _497_/Q VGND VGND VPWR VPWR hold15/X sky130_fd_sc_hd__dlygate4sd3_1
XFILLER_61_57 VPWR VGND VPWR VGND sky130_ef_sc_hd__decap_40_12
XFILLER_51_193 VPWR VGND VPWR VGND sky130_ef_sc_hd__decap_40_12
XFILLER_45_69 VPWR VGND VPWR VGND sky130_ef_sc_hd__decap_40_12
XFILLER_43_149 VPWR VGND VPWR VGND sky130_ef_sc_hd__decap_40_12
XTAP_TAPCELL_ROW_34_380 VGND VPWR sky130_fd_sc_hd__tapvpwrvgnd_1
XTAP_TAPCELL_ROW_26_325 VGND VPWR sky130_fd_sc_hd__tapvpwrvgnd_1
XFILLER_24_363 VGND VGND VPWR VPWR sky130_fd_sc_hd__fill_1
XFILLER_3_223 VGND VGND VPWR VPWR sky130_fd_sc_hd__fill_1
XFILLER_10_83 VGND VGND VPWR VPWR sky130_fd_sc_hd__fill_1
XFILLER_19_113 VPWR VGND VPWR VGND sky130_ef_sc_hd__decap_40_12
XFILLER_59_293 VPWR VGND VPWR VGND sky130_ef_sc_hd__decap_40_12
XFILLER_19_81 VPWR VGND VPWR VGND sky130_ef_sc_hd__decap_40_12
XFILLER_15_385 VGND VGND VPWR VPWR sky130_fd_sc_hd__fill_4
XFILLER_25_105 VGND VGND VPWR VPWR sky130_fd_sc_hd__fill_4
XFILLER_25_149 VPWR VGND VPWR VGND sky130_ef_sc_hd__decap_40_12
XFILLER_15_39 VPWR VGND VPWR VGND sky130_ef_sc_hd__decap_40_12
XFILLER_21_355 VGND VGND VPWR VPWR sky130_fd_sc_hd__fill_8
XFILLER_31_27 VPWR VGND VPWR VGND sky130_ef_sc_hd__decap_40_12
XFILLER_0_237 VPWR VGND VPWR VGND sky130_ef_sc_hd__decap_40_12
XFILLER_12_333 VPWR VGND VPWR VGND sky130_ef_sc_hd__decap_40_12
XFILLER_12_377 VPWR VGND VPWR VGND sky130_ef_sc_hd__decap_40_12
XFILLER_24_193 VGND VGND VPWR VPWR sky130_fd_sc_hd__fill_2
XFILLER_21_93 VPWR VGND VPWR VGND sky130_ef_sc_hd__decap_40_12
XFILLER_62_277 VPWR VGND VPWR VGND sky130_ef_sc_hd__decap_40_12
XFILLER_62_233 VPWR VGND VPWR VGND sky130_ef_sc_hd__decap_40_12
XTAP_TAPCELL_ROW_45_453 VGND VPWR sky130_fd_sc_hd__tapvpwrvgnd_1
Xclkbuf_0_clk clk VGND VGND VPWR VPWR clkbuf_0_clk/X sky130_fd_sc_hd__clkbuf_16
XFILLER_15_193 VPWR VGND VPWR VGND sky130_ef_sc_hd__decap_40_12
XFILLER_30_141 VPWR VGND VPWR VGND sky130_ef_sc_hd__decap_40_12
XFILLER_7_51 VGND VGND VPWR VPWR sky130_fd_sc_hd__fill_4
XPHY_EDGE_ROW_15_Right_15 VGND VGND VPWR VPWR sky130_fd_sc_hd__decap_3
XFILLER_26_27 VGND VGND VPWR VPWR sky130_fd_sc_hd__fill_1
XPHY_EDGE_ROW_24_Right_24 VGND VGND VPWR VPWR sky130_fd_sc_hd__decap_3
XFILLER_53_277 VGND VGND VPWR VPWR sky130_fd_sc_hd__fill_2
XFILLER_42_15 VPWR VGND VPWR VGND sky130_ef_sc_hd__decap_40_12
XPHY_EDGE_ROW_33_Right_33 VGND VGND VPWR VPWR sky130_fd_sc_hd__decap_3
XFILLER_5_329 VGND VGND VPWR VPWR sky130_fd_sc_hd__fill_4
XTAP_TAPCELL_ROW_59_556 VGND VPWR sky130_fd_sc_hd__tapvpwrvgnd_1
XFILLER_44_211 VGND VGND VPWR VPWR sky130_fd_sc_hd__fill_1
XPHY_EDGE_ROW_42_Right_42 VGND VGND VPWR VPWR sky130_fd_sc_hd__decap_3
XTAP_TAPCELL_ROW_42_434 VGND VPWR sky130_fd_sc_hd__tapvpwrvgnd_1
XFILLER_32_406 VGND VGND VPWR VPWR sky130_fd_sc_hd__fill_1
X_484_ _484_/A1 _293_/B _447_/C _565_/Q _248_/Y VGND VGND VPWR VPWR _484_/X sky130_fd_sc_hd__o221a_1
X_553_ _564_/CLK _553_/D VGND VGND VPWR VPWR _553_/Q sky130_fd_sc_hd__dfxtp_1
XPHY_EDGE_ROW_51_Right_51 VGND VGND VPWR VPWR sky130_fd_sc_hd__decap_3
XFILLER_32_81 VGND VGND VPWR VPWR sky130_fd_sc_hd__fill_2
XFILLER_8_189 VGND VGND VPWR VPWR sky130_fd_sc_hd__fill_4
XFILLER_12_141 VPWR VGND VPWR VGND sky130_ef_sc_hd__decap_40_12
XPHY_EDGE_ROW_60_Right_60 VGND VGND VPWR VPWR sky130_fd_sc_hd__decap_3
XFILLER_35_233 VGND VGND VPWR VPWR sky130_fd_sc_hd__fill_2
XPHY_EDGE_ROW_35_Left_100 VGND VGND VPWR VPWR sky130_fd_sc_hd__decap_3
XFILLER_23_406 VGND VGND VPWR VPWR sky130_fd_sc_hd__fill_1
Xhold123 _523_/Q VGND VGND VPWR VPWR _382_/A sky130_fd_sc_hd__dlygate4sd3_1
Xhold101 _543_/Q VGND VGND VPWR VPWR _390_/D sky130_fd_sc_hd__dlygate4sd3_1
Xhold134 _419_/Y VGND VGND VPWR VPWR _420_/B sky130_fd_sc_hd__dlygate4sd3_1
Xhold145 _479_/X VGND VGND VPWR VPWR _481_/B sky130_fd_sc_hd__dlygate4sd3_1
Xhold167 _486_/Q VGND VGND VPWR VPWR _432_/C1 sky130_fd_sc_hd__dlygate4sd3_1
XFILLER_12_29 VPWR VGND VPWR VGND sky130_ef_sc_hd__decap_40_12
Xhold156 _560_/Q VGND VGND VPWR VPWR _472_/A sky130_fd_sc_hd__dlygate4sd3_1
Xhold112 _286_/X VGND VGND VPWR VPWR _486_/D sky130_fd_sc_hd__dlygate4sd3_1
XFILLER_37_15 VPWR VGND VPWR VGND sky130_ef_sc_hd__decap_40_12
XTAP_TAPCELL_ROW_64_592 VGND VPWR sky130_fd_sc_hd__tapvpwrvgnd_1
XFILLER_53_69 VPWR VGND VPWR VGND sky130_ef_sc_hd__decap_40_12
XFILLER_5_137 VPWR VGND VPWR VGND sky130_ef_sc_hd__decap_40_12
XFILLER_57_391 VGND VGND VPWR VPWR sky130_fd_sc_hd__fill_1
XFILLER_27_81 VPWR VGND VPWR VGND sky130_ef_sc_hd__decap_40_12
XTAP_TAPCELL_ROW_4_170 VGND VPWR sky130_fd_sc_hd__tapvpwrvgnd_1
X_536_ _539_/CLK _536_/D VGND VGND VPWR VPWR _536_/Q sky130_fd_sc_hd__dfxtp_1
X_398_ _403_/C _403_/D VGND VGND VPWR VPWR _398_/X sky130_fd_sc_hd__and2_1
XFILLER_17_277 VGND VGND VPWR VPWR sky130_fd_sc_hd__fill_2
X_467_ _466_/A _465_/A _481_/A VGND VGND VPWR VPWR _467_/Y sky130_fd_sc_hd__o21ai_1
XFILLER_4_85 VPWR VGND VPWR VGND sky130_ef_sc_hd__decap_40_12
XFILLER_4_41 VPWR VGND VPWR VGND sky130_ef_sc_hd__decap_40_12
XFILLER_63_361 VPWR VGND VPWR VGND sky130_ef_sc_hd__decap_40_12
XFILLER_55_317 VPWR VGND VPWR VGND sky130_ef_sc_hd__decap_40_12
XFILLER_23_225 VGND VGND VPWR VPWR sky130_fd_sc_hd__fill_8
XFILLER_23_39 VPWR VGND VPWR VGND sky130_ef_sc_hd__decap_40_12
XFILLER_58_177 VPWR VGND VPWR VGND sky130_ef_sc_hd__decap_40_12
XFILLER_58_133 VGND VGND VPWR VPWR sky130_fd_sc_hd__fill_4
XFILLER_64_57 VPWR VGND VPWR VGND sky130_ef_sc_hd__decap_40_12
XFILLER_54_361 VGND VGND VPWR VPWR sky130_fd_sc_hd__fill_2
X_252_ _256_/B _252_/B VGND VGND VPWR VPWR _403_/C sky130_fd_sc_hd__and2_1
X_321_ _333_/A _321_/B VGND VGND VPWR VPWR _321_/X sky130_fd_sc_hd__or2_1
XFILLER_49_111 VGND VGND VPWR VPWR sky130_fd_sc_hd__fill_1
XFILLER_29_8 VPWR VGND VPWR VGND sky130_ef_sc_hd__decap_40_12
XFILLER_64_169 VPWR VGND VPWR VGND sky130_ef_sc_hd__decap_40_12
XFILLER_64_125 VPWR VGND VPWR VGND sky130_ef_sc_hd__decap_40_12
XFILLER_52_309 VPWR VGND VPWR VGND sky130_ef_sc_hd__decap_40_12
XFILLER_45_361 VPWR VGND VPWR VGND sky130_ef_sc_hd__decap_40_12
X_519_ _523_/CLK _519_/D VGND VGND VPWR VPWR _519_/Q sky130_fd_sc_hd__dfxtp_1
XFILLER_9_273 VGND VGND VPWR VPWR sky130_fd_sc_hd__fill_4
XTAP_TAPCELL_ROW_15_242 VGND VPWR sky130_fd_sc_hd__tapvpwrvgnd_1
XFILLER_55_125 VPWR VGND VPWR VGND sky130_ef_sc_hd__decap_40_12
XFILLER_55_169 VPWR VGND VPWR VGND sky130_ef_sc_hd__decap_40_12
XFILLER_34_27 VGND VGND VPWR VPWR sky130_fd_sc_hd__fill_1
XFILLER_11_217 VGND VGND VPWR VPWR sky130_fd_sc_hd__fill_4
XFILLER_50_15 VPWR VGND VPWR VGND sky130_ef_sc_hd__decap_40_12
XFILLER_3_405 VGND VGND VPWR VPWR sky130_fd_sc_hd__fill_2
XTAP_TAPCELL_ROW_21_289 VGND VPWR sky130_fd_sc_hd__tapvpwrvgnd_1
Xclkload4 _564_/CLK VGND VGND VPWR VPWR clkload4/Y sky130_fd_sc_hd__clkinv_2
XFILLER_59_57 VPWR VGND VPWR VGND sky130_ef_sc_hd__decap_40_12
XTAP_TAPCELL_ROW_29_345 VGND VPWR sky130_fd_sc_hd__tapvpwrvgnd_1
XFILLER_42_397 VGND VGND VPWR VPWR sky130_fd_sc_hd__fill_2
X_304_ _304_/A _306_/B VGND VGND VPWR VPWR _304_/X sky130_fd_sc_hd__or2_1
XTAP_TAPCELL_ROW_12_223 VGND VPWR sky130_fd_sc_hd__tapvpwrvgnd_1
XFILLER_40_81 VGND VGND VPWR VPWR sky130_fd_sc_hd__fill_2
XFILLER_6_221 VPWR VGND VPWR VGND sky130_ef_sc_hd__decap_40_12
XFILLER_6_265 VPWR VGND VPWR VGND sky130_ef_sc_hd__decap_40_12
XFILLER_37_125 VPWR VGND VPWR VGND sky130_ef_sc_hd__decap_40_12
XFILLER_52_139 VGND VGND VPWR VPWR sky130_fd_sc_hd__fill_1
XFILLER_18_361 VGND VGND VPWR VPWR sky130_fd_sc_hd__fill_2
XFILLER_20_29 VPWR VGND VPWR VGND sky130_ef_sc_hd__decap_40_12
Xhold38 _364_/X VGND VGND VPWR VPWR hold38/X sky130_fd_sc_hd__dlygate4sd3_1
Xhold27 _371_/X VGND VGND VPWR VPWR _519_/D sky130_fd_sc_hd__dlygate4sd3_1
Xhold16 _315_/X VGND VGND VPWR VPWR _497_/D sky130_fd_sc_hd__dlygate4sd3_1
XFILLER_56_401 VGND VGND VPWR VPWR sky130_fd_sc_hd__fill_4
XFILLER_45_15 VPWR VGND VPWR VGND sky130_ef_sc_hd__decap_40_12
Xhold49 _253_/Y VGND VGND VPWR VPWR _255_/C sky130_fd_sc_hd__dlygate4sd3_1
XFILLER_16_309 VPWR VGND VPWR VGND sky130_ef_sc_hd__decap_40_12
XFILLER_61_69 VPWR VGND VPWR VGND sky130_ef_sc_hd__decap_40_12
XFILLER_51_161 VGND VGND VPWR VPWR sky130_fd_sc_hd__fill_4
XTAP_TAPCELL_ROW_34_381 VGND VPWR sky130_fd_sc_hd__tapvpwrvgnd_1
XFILLER_59_261 VPWR VGND VPWR VGND sky130_ef_sc_hd__decap_40_12
XFILLER_3_279 VGND VGND VPWR VPWR sky130_fd_sc_hd__fill_1
XFILLER_19_125 VPWR VGND VPWR VGND sky130_ef_sc_hd__decap_40_12
XFILLER_35_81 VPWR VGND VPWR VGND sky130_ef_sc_hd__decap_40_12
XFILLER_34_139 VGND VGND VPWR VPWR sky130_fd_sc_hd__fill_1
XFILLER_19_93 VPWR VGND VPWR VGND sky130_ef_sc_hd__decap_40_12
XFILLER_19_169 VPWR VGND VPWR VGND sky130_ef_sc_hd__decap_40_12
XFILLER_42_183 VPWR VGND VPWR VGND sky130_ef_sc_hd__decap_40_12
XFILLER_32_3 VPWR VGND VPWR VGND sky130_ef_sc_hd__decap_40_12
XTAP_TAPCELL_ROW_48_473 VGND VPWR sky130_fd_sc_hd__tapvpwrvgnd_1
XFILLER_40_109 VPWR VGND VPWR VGND sky130_ef_sc_hd__decap_40_12
XFILLER_31_39 VPWR VGND VPWR VGND sky130_ef_sc_hd__decap_40_12
XFILLER_48_209 VPWR VGND VPWR VGND sky130_ef_sc_hd__decap_40_12
XFILLER_0_249 VGND VGND VPWR VPWR sky130_fd_sc_hd__fill_2
XFILLER_56_253 VPWR VGND VPWR VGND sky130_ef_sc_hd__decap_40_12
XFILLER_31_109 VGND VGND VPWR VPWR sky130_fd_sc_hd__fill_2
XFILLER_12_301 VGND VGND VPWR VPWR sky130_fd_sc_hd__fill_4
XFILLER_16_139 VGND VGND VPWR VPWR sky130_fd_sc_hd__fill_1
XFILLER_8_305 VGND VGND VPWR VPWR sky130_fd_sc_hd__fill_2
XFILLER_12_345 VPWR VGND VPWR VGND sky130_ef_sc_hd__decap_40_12
XFILLER_12_389 VPWR VGND VPWR VGND sky130_ef_sc_hd__decap_40_12
XFILLER_62_289 VPWR VGND VPWR VGND sky130_ef_sc_hd__decap_40_12
XFILLER_62_245 VGND VGND VPWR VPWR sky130_fd_sc_hd__fill_4
XTAP_TAPCELL_ROW_45_454 VGND VPWR sky130_fd_sc_hd__tapvpwrvgnd_1
XFILLER_30_153 VPWR VGND VPWR VGND sky130_ef_sc_hd__decap_40_12
XFILLER_15_161 VGND VGND VPWR VPWR sky130_fd_sc_hd__fill_4
XFILLER_22_109 VPWR VGND VPWR VGND sky130_ef_sc_hd__decap_40_12
XFILLER_7_393 VPWR VGND VPWR VGND sky130_ef_sc_hd__decap_40_12
XFILLER_53_223 VGND VGND VPWR VPWR sky130_fd_sc_hd__fill_1
XFILLER_38_286 VGND VGND VPWR VPWR sky130_fd_sc_hd__fill_4
XFILLER_13_109 VGND VGND VPWR VPWR sky130_fd_sc_hd__fill_2
XFILLER_42_27 VGND VGND VPWR VPWR sky130_fd_sc_hd__fill_1
XTAP_TAPCELL_ROW_42_435 VGND VPWR sky130_fd_sc_hd__tapvpwrvgnd_1
X_483_ _243_/Y _481_/C _482_/X _481_/A VGND VGND VPWR VPWR _483_/X sky130_fd_sc_hd__o211a_1
XFILLER_12_153 VPWR VGND VPWR VGND sky130_ef_sc_hd__decap_40_12
XFILLER_16_83 VGND VGND VPWR VPWR sky130_fd_sc_hd__fill_1
X_552_ _564_/CLK _552_/D VGND VGND VPWR VPWR _552_/Q sky130_fd_sc_hd__dfxtp_1
XTAP_TAPCELL_ROW_50_490 VGND VPWR sky130_fd_sc_hd__tapvpwrvgnd_1
XFILLER_12_197 VPWR VGND VPWR VGND sky130_ef_sc_hd__decap_40_12
XFILLER_4_363 VGND VGND VPWR VPWR sky130_fd_sc_hd__fill_1
XTAP_TAPCELL_ROW_7_190 VGND VPWR sky130_fd_sc_hd__tapvpwrvgnd_1
XFILLER_35_223 VGND VGND VPWR VPWR sky130_fd_sc_hd__fill_1
XFILLER_35_201 VGND VGND VPWR VPWR sky130_fd_sc_hd__fill_1
Xhold102 _524_/Q VGND VGND VPWR VPWR _385_/A sky130_fd_sc_hd__dlygate4sd3_1
Xhold113 _537_/Q VGND VGND VPWR VPWR _421_/A sky130_fd_sc_hd__dlygate4sd3_1
Xhold135 _420_/Y VGND VGND VPWR VPWR _536_/D sky130_fd_sc_hd__dlygate4sd3_1
Xhold124 _531_/Q VGND VGND VPWR VPWR _403_/A sky130_fd_sc_hd__dlygate4sd3_1
Xhold146 _481_/X VGND VGND VPWR VPWR _563_/D sky130_fd_sc_hd__dlygate4sd3_1
Xhold168 _445_/X VGND VGND VPWR VPWR _550_/D sky130_fd_sc_hd__dlygate4sd3_1
Xhold157 _473_/X VGND VGND VPWR VPWR _560_/D sky130_fd_sc_hd__dlygate4sd3_1
XFILLER_37_27 VPWR VGND VPWR VGND sky130_ef_sc_hd__decap_40_12
XTAP_TAPCELL_ROW_64_593 VGND VPWR sky130_fd_sc_hd__tapvpwrvgnd_1
XFILLER_53_15 VPWR VGND VPWR VGND sky130_ef_sc_hd__decap_40_12
XFILLER_26_267 VGND VGND VPWR VPWR sky130_fd_sc_hd__fill_1
XFILLER_5_149 VPWR VGND VPWR VGND sky130_ef_sc_hd__decap_40_12
XFILLER_5_105 VGND VGND VPWR VPWR sky130_fd_sc_hd__fill_4
XFILLER_49_337 VPWR VGND VPWR VGND sky130_ef_sc_hd__decap_40_12
XFILLER_1_333 VGND VGND VPWR VPWR sky130_fd_sc_hd__fill_2
XFILLER_64_307 VGND VGND VPWR VPWR sky130_fd_sc_hd__fill_1
X_535_ _539_/CLK _535_/D VGND VGND VPWR VPWR _535_/Q sky130_fd_sc_hd__dfxtp_1
XFILLER_27_93 VPWR VGND VPWR VGND sky130_ef_sc_hd__decap_40_12
XTAP_TAPCELL_ROW_4_171 VGND VPWR sky130_fd_sc_hd__tapvpwrvgnd_1
XFILLER_17_223 VGND VGND VPWR VPWR sky130_fd_sc_hd__fill_1
XFILLER_43_81 VPWR VGND VPWR VGND sky130_ef_sc_hd__decap_40_12
XFILLER_40_270 VGND VGND VPWR VPWR sky130_fd_sc_hd__fill_1
XFILLER_32_226 VGND VGND VPWR VPWR sky130_fd_sc_hd__fill_1
X_397_ _252_/B _403_/D _256_/B VGND VGND VPWR VPWR _399_/C sky130_fd_sc_hd__a21o_1
X_466_ _466_/A _466_/B _466_/C _466_/D VGND VGND VPWR VPWR _474_/D sky130_fd_sc_hd__and4_1
XFILLER_4_193 VGND VGND VPWR VPWR sky130_fd_sc_hd__fill_2
XFILLER_55_329 VGND VGND VPWR VPWR sky130_fd_sc_hd__fill_4
XFILLER_4_97 VPWR VGND VPWR VGND sky130_ef_sc_hd__decap_40_12
XFILLER_4_53 VPWR VGND VPWR VGND sky130_ef_sc_hd__decap_40_12
XFILLER_63_373 VPWR VGND VPWR VGND sky130_ef_sc_hd__decap_40_12
XTAP_TAPCELL_ROW_53_508 VGND VPWR sky130_fd_sc_hd__tapvpwrvgnd_1
XANTENNA__307__A2 _283_/X VGND VGND VPWR VPWR sky130_fd_sc_hd__diode_2
XFILLER_48_15 VPWR VGND VPWR VGND sky130_ef_sc_hd__decap_40_12
XPHY_EDGE_ROW_18_Left_83 VGND VGND VPWR VPWR sky130_fd_sc_hd__decap_3
XFILLER_64_69 VPWR VGND VPWR VGND sky130_ef_sc_hd__decap_40_12
XFILLER_58_189 VGND VGND VPWR VPWR sky130_fd_sc_hd__fill_4
XFILLER_46_307 VGND VGND VPWR VPWR sky130_fd_sc_hd__fill_1
XFILLER_39_370 VGND VGND VPWR VPWR sky130_fd_sc_hd__fill_2
XPHY_EDGE_ROW_54_Left_119 VGND VGND VPWR VPWR sky130_fd_sc_hd__decap_3
X_251_ _539_/Q _538_/Q _536_/Q _537_/Q VGND VGND VPWR VPWR _255_/B sky130_fd_sc_hd__or4b_1
X_320_ hold70/X hold92/X _332_/S VGND VGND VPWR VPWR _320_/X sky130_fd_sc_hd__mux2_1
XFILLER_13_51 VGND VGND VPWR VPWR sky130_fd_sc_hd__fill_4
XPHY_EDGE_ROW_63_Left_128 VGND VGND VPWR VPWR sky130_fd_sc_hd__decap_3
XFILLER_49_167 VGND VGND VPWR VPWR sky130_fd_sc_hd__fill_1
XFILLER_38_81 VGND VGND VPWR VPWR sky130_fd_sc_hd__fill_2
XFILLER_64_137 VGND VGND VPWR VPWR sky130_fd_sc_hd__fill_2
XFILLER_60_365 VPWR VGND VPWR VGND sky130_ef_sc_hd__decap_40_12
XFILLER_60_321 VPWR VGND VPWR VGND sky130_ef_sc_hd__decap_40_12
XFILLER_45_373 VPWR VGND VPWR VGND sky130_ef_sc_hd__decap_40_12
X_518_ _523_/CLK _518_/D VGND VGND VPWR VPWR _518_/Q sky130_fd_sc_hd__dfxtp_1
XTAP_TAPCELL_ROW_15_243 VGND VPWR sky130_fd_sc_hd__tapvpwrvgnd_1
XFILLER_62_3 VPWR VGND VPWR VGND sky130_ef_sc_hd__decap_40_12
XFILLER_13_281 VPWR VGND VPWR VGND sky130_ef_sc_hd__decap_40_12
X_449_ _452_/B _458_/C _481_/A VGND VGND VPWR VPWR _449_/Y sky130_fd_sc_hd__o21ai_1
XFILLER_55_137 VPWR VGND VPWR VGND sky130_ef_sc_hd__decap_40_12
XFILLER_28_307 VGND VGND VPWR VPWR sky130_fd_sc_hd__fill_1
XFILLER_18_29 VPWR VGND VPWR VGND sky130_ef_sc_hd__decap_40_12
XFILLER_63_181 VPWR VGND VPWR VGND sky130_ef_sc_hd__decap_40_12
Xclkload5 _565_/CLK VGND VGND VPWR VPWR clkload5/Y sky130_fd_sc_hd__clkinv_2
XFILLER_50_27 VGND VGND VPWR VPWR sky130_fd_sc_hd__fill_1
XFILLER_59_69 VPWR VGND VPWR VGND sky130_ef_sc_hd__decap_40_12
XPHY_EDGE_ROW_3_Left_68 VGND VGND VPWR VPWR sky130_fd_sc_hd__decap_3
XFILLER_46_137 VGND VGND VPWR VPWR sky130_fd_sc_hd__fill_2
XFILLER_42_321 VGND VGND VPWR VPWR sky130_fd_sc_hd__fill_2
XTAP_TAPCELL_ROW_29_346 VGND VPWR sky130_fd_sc_hd__tapvpwrvgnd_1
XFILLER_42_365 VPWR VGND VPWR VGND sky130_ef_sc_hd__decap_40_12
X_303_ _341_/B _283_/X hold79/X _273_/A VGND VGND VPWR VPWR _303_/X sky130_fd_sc_hd__o211a_1
XFILLER_6_233 VPWR VGND VPWR VGND sky130_ef_sc_hd__decap_40_12
XFILLER_10_251 VGND VGND VPWR VPWR sky130_fd_sc_hd__fill_1
XTAP_TAPCELL_ROW_12_224 VGND VPWR sky130_fd_sc_hd__tapvpwrvgnd_1
XFILLER_24_83 VGND VGND VPWR VPWR sky130_fd_sc_hd__fill_1
XFILLER_6_277 VPWR VGND VPWR VGND sky130_ef_sc_hd__decap_40_12
XFILLER_37_137 VPWR VGND VPWR VGND sky130_ef_sc_hd__decap_40_12
XFILLER_60_195 VGND VGND VPWR VPWR sky130_fd_sc_hd__fill_1
XFILLER_45_181 VPWR VGND VPWR VGND sky130_ef_sc_hd__decap_40_12
Xhold39 _365_/X VGND VGND VPWR VPWR _516_/D sky130_fd_sc_hd__dlygate4sd3_1
Xhold28 _559_/Q VGND VGND VPWR VPWR _474_/C sky130_fd_sc_hd__dlygate4sd3_1
Xhold17 _552_/Q VGND VGND VPWR VPWR _452_/B sky130_fd_sc_hd__dlygate4sd3_1
XFILLER_45_27 VPWR VGND VPWR VGND sky130_ef_sc_hd__decap_40_12
XFILLER_28_137 VGND VGND VPWR VPWR sky130_fd_sc_hd__fill_2
XFILLER_61_15 VPWR VGND VPWR VGND sky130_ef_sc_hd__decap_40_12
XFILLER_3_225 VPWR VGND VPWR VGND sky130_ef_sc_hd__decap_40_12
XFILLER_10_41 VPWR VGND VPWR VGND sky130_ef_sc_hd__decap_40_12
XFILLER_10_85 VPWR VGND VPWR VGND sky130_ef_sc_hd__decap_40_12
XFILLER_62_405 VGND VGND VPWR VPWR sky130_fd_sc_hd__fill_2
XFILLER_59_273 VGND VGND VPWR VPWR sky130_fd_sc_hd__fill_4
XFILLER_19_137 VPWR VGND VPWR VGND sky130_ef_sc_hd__decap_40_12
XFILLER_42_195 VGND VGND VPWR VPWR sky130_fd_sc_hd__fill_1
XFILLER_42_173 VGND VGND VPWR VPWR sky130_fd_sc_hd__fill_2
XFILLER_35_93 VPWR VGND VPWR VGND sky130_ef_sc_hd__decap_40_12
XFILLER_27_181 VPWR VGND VPWR VGND sky130_ef_sc_hd__decap_40_12
XFILLER_51_81 VPWR VGND VPWR VGND sky130_ef_sc_hd__decap_40_12
XFILLER_30_357 VGND VGND VPWR VPWR sky130_fd_sc_hd__fill_1
XFILLER_25_3 VPWR VGND VPWR VGND sky130_ef_sc_hd__decap_40_12
XFILLER_53_405 VGND VGND VPWR VPWR sky130_fd_sc_hd__fill_2
XTAP_TAPCELL_ROW_48_474 VGND VPWR sky130_fd_sc_hd__tapvpwrvgnd_1
XFILLER_33_151 VGND VGND VPWR VPWR sky130_fd_sc_hd__fill_1
XFILLER_21_335 VGND VGND VPWR VPWR sky130_fd_sc_hd__fill_1
XFILLER_56_265 VPWR VGND VPWR VGND sky130_ef_sc_hd__decap_40_12
XFILLER_56_221 VPWR VGND VPWR VGND sky130_ef_sc_hd__decap_40_12
XFILLER_56_15 VPWR VGND VPWR VGND sky130_ef_sc_hd__decap_40_12
XFILLER_44_405 VGND VGND VPWR VPWR sky130_fd_sc_hd__fill_2
XFILLER_24_195 VGND VGND VPWR VPWR sky130_fd_sc_hd__fill_1
XFILLER_12_357 VGND VGND VPWR VPWR sky130_fd_sc_hd__fill_4
XFILLER_21_51 VGND VGND VPWR VPWR sky130_fd_sc_hd__fill_4
XFILLER_47_221 VGND VGND VPWR VPWR sky130_fd_sc_hd__fill_2
XFILLER_46_81 VGND VGND VPWR VPWR sky130_fd_sc_hd__fill_2
XPHY_EDGE_ROW_6_Left_71 VGND VGND VPWR VPWR sky130_fd_sc_hd__decap_3
XTAP_TAPCELL_ROW_45_455 VGND VPWR sky130_fd_sc_hd__tapvpwrvgnd_1
XFILLER_30_165 VGND VGND VPWR VPWR sky130_fd_sc_hd__fill_1
XFILLER_30_121 VPWR VGND VPWR VGND sky130_ef_sc_hd__decap_40_12
XFILLER_7_361 VPWR VGND VPWR VGND sky130_ef_sc_hd__decap_40_12
XFILLER_53_279 VGND VGND VPWR VPWR sky130_fd_sc_hd__fill_1
XFILLER_38_298 VGND VGND VPWR VPWR sky130_fd_sc_hd__fill_1
XFILLER_26_29 VPWR VGND VPWR VGND sky130_ef_sc_hd__decap_40_12
XPHY_EDGE_ROW_5_Right_5 VGND VGND VPWR VPWR sky130_fd_sc_hd__decap_3
XFILLER_21_165 VGND VGND VPWR VPWR sky130_fd_sc_hd__fill_2
XFILLER_29_210 VGND VGND VPWR VPWR sky130_fd_sc_hd__fill_2
XFILLER_17_405 VGND VGND VPWR VPWR sky130_fd_sc_hd__fill_2
X_551_ _564_/CLK _551_/D VGND VGND VPWR VPWR _551_/Q sky130_fd_sc_hd__dfxtp_1
XTAP_TAPCELL_ROW_42_436 VGND VPWR sky130_fd_sc_hd__tapvpwrvgnd_1
XPHY_EDGE_ROW_32_Left_97 VGND VGND VPWR VPWR sky130_fd_sc_hd__decap_3
XFILLER_12_121 VPWR VGND VPWR VGND sky130_ef_sc_hd__decap_40_12
XFILLER_12_165 VPWR VGND VPWR VGND sky130_ef_sc_hd__decap_40_12
X_482_ _563_/Q _480_/B _480_/C _277_/A VGND VGND VPWR VPWR _482_/X sky130_fd_sc_hd__a31o_1
XTAP_TAPCELL_ROW_50_491 VGND VPWR sky130_fd_sc_hd__tapvpwrvgnd_1
XFILLER_32_83 VGND VGND VPWR VPWR sky130_fd_sc_hd__fill_1
XTAP_TAPCELL_ROW_7_191 VGND VPWR sky130_fd_sc_hd__tapvpwrvgnd_1
XFILLER_50_249 VGND VGND VPWR VPWR sky130_fd_sc_hd__fill_2
XFILLER_43_290 VGND VGND VPWR VPWR sky130_fd_sc_hd__fill_1
XFILLER_58_305 VGND VGND VPWR VPWR sky130_fd_sc_hd__fill_2
Xhold103 _385_/Y VGND VGND VPWR VPWR _386_/C sky130_fd_sc_hd__dlygate4sd3_1
Xhold114 _422_/Y VGND VGND VPWR VPWR _423_/B sky130_fd_sc_hd__dlygate4sd3_1
Xhold158 _535_/Q VGND VGND VPWR VPWR _415_/A sky130_fd_sc_hd__dlygate4sd3_1
Xhold125 _404_/Y VGND VGND VPWR VPWR _405_/B sky130_fd_sc_hd__dlygate4sd3_1
Xhold169 _548_/Q VGND VGND VPWR VPWR _442_/B sky130_fd_sc_hd__dlygate4sd3_1
Xhold147 _555_/Q VGND VGND VPWR VPWR _458_/A sky130_fd_sc_hd__dlygate4sd3_1
Xhold136 _488_/Q VGND VGND VPWR VPWR _447_/B sky130_fd_sc_hd__dlygate4sd3_1
XFILLER_37_39 VPWR VGND VPWR VGND sky130_ef_sc_hd__decap_40_12
XTAP_TAPCELL_ROW_64_594 VGND VPWR sky130_fd_sc_hd__tapvpwrvgnd_1
XFILLER_53_27 VPWR VGND VPWR VGND sky130_ef_sc_hd__decap_40_12
XFILLER_49_349 VPWR VGND VPWR VGND sky130_ef_sc_hd__decap_40_12
XFILLER_49_305 VPWR VGND VPWR VGND sky130_ef_sc_hd__decap_40_12
XFILLER_1_389 VGND VGND VPWR VPWR sky130_fd_sc_hd__fill_2
XFILLER_57_393 VPWR VGND VPWR VGND sky130_ef_sc_hd__decap_40_12
X_534_ _539_/CLK _534_/D VGND VGND VPWR VPWR _534_/Q sky130_fd_sc_hd__dfxtp_1
XFILLER_17_279 VGND VGND VPWR VPWR sky130_fd_sc_hd__fill_1
X_465_ _465_/A _465_/B VGND VGND VPWR VPWR _465_/Y sky130_fd_sc_hd__nor2_1
XFILLER_43_93 VPWR VGND VPWR VGND sky130_ef_sc_hd__decap_40_12
XFILLER_40_293 VGND VGND VPWR VPWR sky130_fd_sc_hd__fill_2
XANTENNA_clkbuf_3_7__f_clk_A clkbuf_0_clk/X VGND VGND VPWR VPWR sky130_fd_sc_hd__diode_2
X_396_ _252_/B _403_/D _395_/Y VGND VGND VPWR VPWR _396_/Y sky130_fd_sc_hd__a21oi_1
XFILLER_4_65 VPWR VGND VPWR VGND sky130_ef_sc_hd__decap_40_12
XFILLER_63_385 VGND VGND VPWR VPWR sky130_fd_sc_hd__fill_4
XTAP_TAPCELL_ROW_61_564 VGND VPWR sky130_fd_sc_hd__tapvpwrvgnd_1
XTAP_TAPCELL_ROW_53_509 VGND VPWR sky130_fd_sc_hd__tapvpwrvgnd_1
XTAP_TAPCELL_ROW_18_263 VGND VPWR sky130_fd_sc_hd__tapvpwrvgnd_1
XFILLER_23_205 VPWR VGND VPWR VGND sky130_ef_sc_hd__decap_40_12
XFILLER_2_109 VPWR VGND VPWR VGND sky130_ef_sc_hd__decap_40_12
XFILLER_48_27 VGND VGND VPWR VPWR sky130_fd_sc_hd__fill_1
XFILLER_64_15 VPWR VGND VPWR VGND sky130_ef_sc_hd__decap_40_12
XFILLER_54_363 VGND VGND VPWR VPWR sky130_fd_sc_hd__fill_1
X_250_ _527_/Q _526_/Q VGND VGND VPWR VPWR _268_/A sky130_fd_sc_hd__or2_1
XFILLER_14_249 VGND VGND VPWR VPWR sky130_fd_sc_hd__fill_2
XFILLER_49_113 VPWR VGND VPWR VGND sky130_ef_sc_hd__decap_40_12
XFILLER_60_377 VPWR VGND VPWR VGND sky130_ef_sc_hd__decap_40_12
XFILLER_60_333 VPWR VGND VPWR VGND sky130_ef_sc_hd__decap_40_12
XFILLER_54_81 VGND VGND VPWR VPWR sky130_fd_sc_hd__fill_2
XFILLER_45_385 VGND VGND VPWR VPWR sky130_fd_sc_hd__fill_4
X_517_ _523_/CLK _517_/D VGND VGND VPWR VPWR _517_/Q sky130_fd_sc_hd__dfxtp_1
XTAP_TAPCELL_ROW_15_244 VGND VPWR sky130_fd_sc_hd__tapvpwrvgnd_1
X_448_ _458_/C _448_/B _481_/A VGND VGND VPWR VPWR _551_/D sky130_fd_sc_hd__and3b_1
XFILLER_55_3 VPWR VGND VPWR VGND sky130_ef_sc_hd__decap_40_12
X_379_ _379_/A _379_/B _390_/C _379_/D VGND VGND VPWR VPWR _385_/C sky130_fd_sc_hd__and4_1
XFILLER_13_293 VPWR VGND VPWR VGND sky130_ef_sc_hd__decap_40_12
XFILLER_55_149 VPWR VGND VPWR VGND sky130_ef_sc_hd__decap_40_12
XFILLER_55_105 VGND VGND VPWR VPWR sky130_fd_sc_hd__fill_4
XFILLER_63_193 VPWR VGND VPWR VGND sky130_ef_sc_hd__decap_40_12
XFILLER_51_333 VGND VGND VPWR VPWR sky130_fd_sc_hd__fill_2
Xclkload6 _523_/CLK VGND VGND VPWR VPWR clkload6/X sky130_fd_sc_hd__clkbuf_8
XFILLER_34_29 VPWR VGND VPWR VGND sky130_ef_sc_hd__decap_40_12
XFILLER_59_15 VPWR VGND VPWR VGND sky130_ef_sc_hd__decap_40_12
XFILLER_54_193 VGND VGND VPWR VPWR sky130_fd_sc_hd__fill_2
XFILLER_42_377 VPWR VGND VPWR VGND sky130_ef_sc_hd__decap_40_12
X_302_ _302_/A _306_/B VGND VGND VPWR VPWR _302_/X sky130_fd_sc_hd__or2_1
XFILLER_6_245 VGND VGND VPWR VPWR sky130_fd_sc_hd__fill_4
XTAP_TAPCELL_ROW_12_225 VGND VPWR sky130_fd_sc_hd__tapvpwrvgnd_1
XTAP_TAPCELL_ROW_20_280 VGND VPWR sky130_fd_sc_hd__tapvpwrvgnd_1
XFILLER_49_81 VPWR VGND VPWR VGND sky130_ef_sc_hd__decap_40_12
XFILLER_40_83 VGND VGND VPWR VPWR sky130_fd_sc_hd__fill_1
XFILLER_6_289 VPWR VGND VPWR VGND sky130_ef_sc_hd__decap_40_12
XFILLER_37_149 VPWR VGND VPWR VGND sky130_ef_sc_hd__decap_40_12
XFILLER_37_105 VGND VGND VPWR VPWR sky130_fd_sc_hd__fill_4
XFILLER_1_55 VGND VGND VPWR VPWR sky130_fd_sc_hd__fill_1
XFILLER_18_341 VPWR VGND VPWR VGND sky130_ef_sc_hd__decap_40_12
XFILLER_18_363 VGND VGND VPWR VPWR sky130_fd_sc_hd__fill_1
XFILLER_60_141 VPWR VGND VPWR VGND sky130_ef_sc_hd__decap_40_12
XFILLER_45_193 VPWR VGND VPWR VGND sky130_ef_sc_hd__decap_40_12
Xhold18 _450_/Y VGND VGND VPWR VPWR _552_/D sky130_fd_sc_hd__dlygate4sd3_1
Xhold29 _470_/Y VGND VGND VPWR VPWR _559_/D sky130_fd_sc_hd__dlygate4sd3_1
XFILLER_45_39 VPWR VGND VPWR VGND sky130_ef_sc_hd__decap_40_12
XFILLER_61_27 VPWR VGND VPWR VGND sky130_ef_sc_hd__decap_40_12
XFILLER_3_237 VPWR VGND VPWR VGND sky130_ef_sc_hd__decap_40_12
XFILLER_10_53 VPWR VGND VPWR VGND sky130_ef_sc_hd__decap_40_12
XFILLER_10_97 VPWR VGND VPWR VGND sky130_ef_sc_hd__decap_40_12
XFILLER_19_51 VGND VGND VPWR VPWR sky130_fd_sc_hd__fill_4
XFILLER_19_105 VGND VGND VPWR VPWR sky130_fd_sc_hd__fill_4
XFILLER_19_149 VPWR VGND VPWR VGND sky130_ef_sc_hd__decap_40_12
XFILLER_42_141 VPWR VGND VPWR VGND sky130_ef_sc_hd__decap_40_12
XFILLER_30_336 VGND VGND VPWR VPWR sky130_fd_sc_hd__fill_4
XFILLER_27_193 VPWR VGND VPWR VGND sky130_ef_sc_hd__decap_40_12
XFILLER_15_333 VGND VGND VPWR VPWR sky130_fd_sc_hd__fill_2
XFILLER_51_93 VPWR VGND VPWR VGND sky130_ef_sc_hd__decap_40_12
XFILLER_18_3 VPWR VGND VPWR VGND sky130_ef_sc_hd__decap_40_12
XTAP_TAPCELL_ROW_48_475 VGND VPWR sky130_fd_sc_hd__tapvpwrvgnd_1
XFILLER_18_193 VGND VGND VPWR VPWR sky130_fd_sc_hd__fill_2
XFILLER_56_277 VPWR VGND VPWR VGND sky130_ef_sc_hd__decap_40_12
XFILLER_56_233 VPWR VGND VPWR VGND sky130_ef_sc_hd__decap_40_12
XFILLER_56_27 VGND VGND VPWR VPWR sky130_fd_sc_hd__fill_1
XFILLER_8_307 VGND VGND VPWR VPWR sky130_fd_sc_hd__fill_1
XFILLER_24_141 VPWR VGND VPWR VGND sky130_ef_sc_hd__decap_40_12
XFILLER_47_277 VGND VGND VPWR VPWR sky130_fd_sc_hd__fill_2
XTAP_TAPCELL_ROW_45_456 VGND VPWR sky130_fd_sc_hd__tapvpwrvgnd_1
XFILLER_62_81 VGND VGND VPWR VPWR sky130_fd_sc_hd__fill_2
XFILLER_30_133 VGND VGND VPWR VPWR sky130_fd_sc_hd__fill_4
XFILLER_11_391 VGND VGND VPWR VPWR sky130_fd_sc_hd__fill_1
XFILLER_7_373 VPWR VGND VPWR VGND sky130_ef_sc_hd__decap_40_12
XFILLER_38_277 VGND VGND VPWR VPWR sky130_fd_sc_hd__fill_2
XFILLER_26_406 VGND VGND VPWR VPWR sky130_fd_sc_hd__fill_1
XFILLER_53_225 VPWR VGND VPWR VGND sky130_ef_sc_hd__decap_40_12
XFILLER_42_29 VPWR VGND VPWR VGND sky130_ef_sc_hd__decap_40_12
XFILLER_21_111 VGND VGND VPWR VPWR sky130_fd_sc_hd__fill_1
XFILLER_16_41 VPWR VGND VPWR VGND sky130_ef_sc_hd__decap_40_12
X_550_ _565_/CLK _550_/D VGND VGND VPWR VPWR _550_/Q sky130_fd_sc_hd__dfxtp_1
X_481_ _481_/A _481_/B _481_/C VGND VGND VPWR VPWR _481_/X sky130_fd_sc_hd__and3_1
XTAP_TAPCELL_ROW_50_492 VGND VPWR sky130_fd_sc_hd__tapvpwrvgnd_1
XTAP_TAPCELL_ROW_42_437 VGND VPWR sky130_fd_sc_hd__tapvpwrvgnd_1
XFILLER_8_137 VGND VGND VPWR VPWR sky130_fd_sc_hd__fill_2
XPHY_EDGE_ROW_11_Right_11 VGND VGND VPWR VPWR sky130_fd_sc_hd__decap_3
XFILLER_12_133 VGND VGND VPWR VPWR sky130_fd_sc_hd__fill_4
XFILLER_12_177 VPWR VGND VPWR VGND sky130_ef_sc_hd__decap_40_12
XFILLER_16_85 VPWR VGND VPWR VGND sky130_ef_sc_hd__decap_40_12
XFILLER_4_365 VPWR VGND VPWR VGND sky130_ef_sc_hd__decap_40_12
XFILLER_4_321 VPWR VGND VPWR VGND sky130_ef_sc_hd__decap_40_12
XPHY_EDGE_ROW_20_Right_20 VGND VGND VPWR VPWR sky130_fd_sc_hd__decap_3
XFILLER_57_81 VPWR VGND VPWR VGND sky130_ef_sc_hd__decap_40_12
XTAP_TAPCELL_ROW_7_192 VGND VPWR sky130_fd_sc_hd__tapvpwrvgnd_1
XFILLER_35_225 VGND VGND VPWR VPWR sky130_fd_sc_hd__fill_8
Xhold104 _386_/X VGND VGND VPWR VPWR _524_/D sky130_fd_sc_hd__dlygate4sd3_1
Xhold115 _423_/Y VGND VGND VPWR VPWR _537_/D sky130_fd_sc_hd__dlygate4sd3_1
Xhold126 _405_/Y VGND VGND VPWR VPWR _531_/D sky130_fd_sc_hd__dlygate4sd3_1
XFILLER_7_181 VPWR VGND VPWR VGND sky130_ef_sc_hd__decap_40_12
Xhold159 _416_/Y VGND VGND VPWR VPWR _417_/B sky130_fd_sc_hd__dlygate4sd3_1
Xhold148 _457_/X VGND VGND VPWR VPWR _459_/C sky130_fd_sc_hd__dlygate4sd3_1
Xhold137 _298_/X VGND VGND VPWR VPWR _488_/D sky130_fd_sc_hd__dlygate4sd3_1
XTAP_TAPCELL_ROW_56_529 VGND VPWR sky130_fd_sc_hd__tapvpwrvgnd_1
XTAP_TAPCELL_ROW_64_595 VGND VPWR sky130_fd_sc_hd__tapvpwrvgnd_1
XFILLER_53_39 VPWR VGND VPWR VGND sky130_ef_sc_hd__decap_40_12
XFILLER_64_309 VPWR VGND VPWR VGND sky130_ef_sc_hd__decap_40_12
XFILLER_57_361 VPWR VGND VPWR VGND sky130_ef_sc_hd__decap_40_12
XFILLER_49_317 VPWR VGND VPWR VGND sky130_ef_sc_hd__decap_40_12
XFILLER_1_335 VGND VGND VPWR VPWR sky130_fd_sc_hd__fill_1
XFILLER_32_239 VPWR VGND VPWR VGND sky130_ef_sc_hd__decap_40_12
X_533_ _545_/CLK _533_/D VGND VGND VPWR VPWR _533_/Q sky130_fd_sc_hd__dfxtp_1
XFILLER_27_51 VGND VGND VPWR VPWR sky130_fd_sc_hd__fill_4
XFILLER_17_225 VPWR VGND VPWR VGND sky130_ef_sc_hd__decap_40_12
X_464_ _466_/B _462_/A _481_/A VGND VGND VPWR VPWR _464_/Y sky130_fd_sc_hd__o21ai_1
X_395_ _252_/B _403_/D _428_/A VGND VGND VPWR VPWR _395_/Y sky130_fd_sc_hd__o21ai_1
XFILLER_4_195 VGND VGND VPWR VPWR sky130_fd_sc_hd__fill_1
XFILLER_4_77 VGND VGND VPWR VPWR sky130_fd_sc_hd__fill_4
XFILLER_48_361 VGND VGND VPWR VPWR sky130_fd_sc_hd__fill_2
XTAP_TAPCELL_ROW_61_565 VGND VPWR sky130_fd_sc_hd__tapvpwrvgnd_1
Xclkbuf_3_2__f_clk clkbuf_0_clk/X VGND VGND VPWR VPWR _539_/CLK sky130_fd_sc_hd__clkbuf_16
XFILLER_31_261 VGND VGND VPWR VPWR sky130_fd_sc_hd__fill_2
XTAP_TAPCELL_ROW_18_264 VGND VPWR sky130_fd_sc_hd__tapvpwrvgnd_1
XFILLER_23_217 VGND VGND VPWR VPWR sky130_fd_sc_hd__fill_4
XFILLER_46_309 VPWR VGND VPWR VGND sky130_ef_sc_hd__decap_40_12
XFILLER_64_27 VGND VGND VPWR VPWR sky130_fd_sc_hd__fill_1
XFILLER_6_405 VGND VGND VPWR VPWR sky130_fd_sc_hd__fill_2
XFILLER_10_401 VGND VGND VPWR VPWR sky130_fd_sc_hd__fill_4
XFILLER_1_165 VGND VGND VPWR VPWR sky130_fd_sc_hd__fill_2
XFILLER_64_139 VGND VGND VPWR VPWR sky130_fd_sc_hd__fill_1
XFILLER_49_169 VPWR VGND VPWR VGND sky130_ef_sc_hd__decap_40_12
XFILLER_49_125 VPWR VGND VPWR VGND sky130_ef_sc_hd__decap_40_12
XFILLER_38_83 VGND VGND VPWR VPWR sky130_fd_sc_hd__fill_1
XFILLER_60_389 VPWR VGND VPWR VGND sky130_ef_sc_hd__decap_40_12
XFILLER_60_345 VPWR VGND VPWR VGND sky130_ef_sc_hd__decap_40_12
XFILLER_60_301 VGND VGND VPWR VPWR sky130_fd_sc_hd__fill_4
X_378_ _379_/B _390_/C _379_/D _379_/A VGND VGND VPWR VPWR _380_/C sky130_fd_sc_hd__a31o_1
X_516_ _516_/CLK _516_/D VGND VGND VPWR VPWR _516_/Q sky130_fd_sc_hd__dfxtp_1
XFILLER_9_221 VGND VGND VPWR VPWR sky130_fd_sc_hd__fill_2
XFILLER_13_261 VPWR VGND VPWR VGND sky130_ef_sc_hd__decap_40_12
XTAP_TAPCELL_ROW_15_245 VGND VPWR sky130_fd_sc_hd__tapvpwrvgnd_1
XFILLER_20_209 VPWR VGND VPWR VGND sky130_ef_sc_hd__decap_40_12
X_447_ _447_/A _447_/B _447_/C VGND VGND VPWR VPWR _448_/B sky130_fd_sc_hd__or3_1
XFILLER_48_3 VPWR VGND VPWR VGND sky130_ef_sc_hd__decap_40_12
XFILLER_63_161 VGND VGND VPWR VPWR sky130_fd_sc_hd__fill_4
XFILLER_51_389 VGND VGND VPWR VPWR sky130_fd_sc_hd__fill_2
XFILLER_50_29 VPWR VGND VPWR VGND sky130_ef_sc_hd__decap_40_12
XFILLER_59_27 VPWR VGND VPWR VGND sky130_ef_sc_hd__decap_40_12
XFILLER_46_139 VGND VGND VPWR VPWR sky130_fd_sc_hd__fill_1
XFILLER_27_353 VGND VGND VPWR VPWR sky130_fd_sc_hd__fill_4
XFILLER_61_109 VGND VGND VPWR VPWR sky130_fd_sc_hd__fill_2
XFILLER_42_389 VGND VGND VPWR VPWR sky130_fd_sc_hd__fill_8
XFILLER_42_323 VGND VGND VPWR VPWR sky130_fd_sc_hd__fill_1
X_301_ hold7/X _306_/B _300_/X VGND VGND VPWR VPWR hold8/A sky130_fd_sc_hd__o21ba_1
XTAP_TAPCELL_ROW_12_226 VGND VPWR sky130_fd_sc_hd__tapvpwrvgnd_1
XFILLER_24_41 VPWR VGND VPWR VGND sky130_ef_sc_hd__decap_40_12
XFILLER_24_85 VPWR VGND VPWR VGND sky130_ef_sc_hd__decap_40_12
XFILLER_10_253 VPWR VGND VPWR VGND sky130_ef_sc_hd__decap_40_12
XTAP_TAPCELL_ROW_20_281 VGND VPWR sky130_fd_sc_hd__tapvpwrvgnd_1
XFILLER_49_93 VPWR VGND VPWR VGND sky130_ef_sc_hd__decap_40_12
XFILLER_52_109 VPWR VGND VPWR VGND sky130_ef_sc_hd__decap_40_12
XFILLER_45_161 VGND VGND VPWR VPWR sky130_fd_sc_hd__fill_4
XFILLER_18_353 VGND VGND VPWR VPWR sky130_fd_sc_hd__fill_8
XFILLER_18_386 VPWR VGND VPWR VGND sky130_ef_sc_hd__decap_40_12
XFILLER_60_197 VPWR VGND VPWR VGND sky130_ef_sc_hd__decap_40_12
XFILLER_60_153 VPWR VGND VPWR VGND sky130_ef_sc_hd__decap_40_12
XPHY_EDGE_ROW_49_Right_49 VGND VGND VPWR VPWR sky130_fd_sc_hd__decap_3
XPHY_EDGE_ROW_58_Right_58 VGND VGND VPWR VPWR sky130_fd_sc_hd__decap_3
Xhold19 _512_/Q VGND VGND VPWR VPWR _353_/A sky130_fd_sc_hd__dlygate4sd3_1
XFILLER_28_139 VGND VGND VPWR VPWR sky130_fd_sc_hd__fill_1
XFILLER_61_39 VPWR VGND VPWR VGND sky130_ef_sc_hd__decap_40_12
XFILLER_43_109 VGND VGND VPWR VPWR sky130_fd_sc_hd__fill_2
XFILLER_36_194 VGND VGND VPWR VPWR sky130_fd_sc_hd__fill_2
XFILLER_36_183 VGND VGND VPWR VPWR sky130_fd_sc_hd__fill_2
XFILLER_3_205 VPWR VGND VPWR VGND sky130_ef_sc_hd__decap_40_12
XFILLER_3_249 VPWR VGND VPWR VGND sky130_ef_sc_hd__decap_40_12
XFILLER_10_65 VPWR VGND VPWR VGND sky130_ef_sc_hd__decap_40_12
XFILLER_35_51 VGND VGND VPWR VPWR sky130_fd_sc_hd__fill_4
XFILLER_34_109 VPWR VGND VPWR VGND sky130_ef_sc_hd__decap_40_12
XFILLER_27_161 VGND VGND VPWR VPWR sky130_fd_sc_hd__fill_4
XFILLER_42_153 VPWR VGND VPWR VGND sky130_ef_sc_hd__decap_40_12
XFILLER_30_326 VGND VGND VPWR VPWR sky130_fd_sc_hd__fill_4
XFILLER_15_389 VGND VGND VPWR VPWR sky130_fd_sc_hd__fill_2
XTAP_TAPCELL_ROW_48_476 VGND VPWR sky130_fd_sc_hd__tapvpwrvgnd_1
XFILLER_25_109 VGND VGND VPWR VPWR sky130_fd_sc_hd__fill_2
XFILLER_21_315 VGND VGND VPWR VPWR sky130_fd_sc_hd__fill_1
XFILLER_21_337 VGND VGND VPWR VPWR sky130_fd_sc_hd__fill_2
XTAP_TAPCELL_ROW_31_354 VGND VPWR sky130_fd_sc_hd__tapvpwrvgnd_1
XFILLER_56_289 VPWR VGND VPWR VGND sky130_ef_sc_hd__decap_40_12
XFILLER_56_245 VGND VGND VPWR VPWR sky130_fd_sc_hd__fill_4
XTAP_TAPCELL_ROW_39_410 VGND VPWR sky130_fd_sc_hd__tapvpwrvgnd_1
XFILLER_16_109 VPWR VGND VPWR VGND sky130_ef_sc_hd__decap_40_12
XFILLER_24_153 VPWR VGND VPWR VGND sky130_ef_sc_hd__decap_40_12
XFILLER_24_197 VPWR VGND VPWR VGND sky130_ef_sc_hd__decap_40_12
XFILLER_47_223 VGND VGND VPWR VPWR sky130_fd_sc_hd__fill_1
XFILLER_46_83 VGND VGND VPWR VPWR sky130_fd_sc_hd__fill_1
XTAP_TAPCELL_ROW_45_457 VGND VPWR sky130_fd_sc_hd__tapvpwrvgnd_1
XFILLER_7_55 VGND VGND VPWR VPWR sky130_fd_sc_hd__fill_1
XFILLER_30_3 VPWR VGND VPWR VGND sky130_ef_sc_hd__decap_40_12
XFILLER_7_385 VGND VGND VPWR VPWR sky130_fd_sc_hd__fill_4
XFILLER_53_237 VPWR VGND VPWR VGND sky130_ef_sc_hd__decap_40_12
XFILLER_61_281 VPWR VGND VPWR VGND sky130_ef_sc_hd__decap_40_12
XFILLER_21_167 VGND VGND VPWR VPWR sky130_fd_sc_hd__fill_1
XFILLER_29_223 VGND VGND VPWR VPWR sky130_fd_sc_hd__fill_1
XFILLER_29_212 VGND VGND VPWR VPWR sky130_fd_sc_hd__fill_1
XFILLER_29_201 VGND VGND VPWR VPWR sky130_fd_sc_hd__fill_1
X_480_ _480_/A _480_/B _480_/C VGND VGND VPWR VPWR _481_/C sky130_fd_sc_hd__nand3_1
XFILLER_16_53 VPWR VGND VPWR VGND sky130_ef_sc_hd__decap_40_12
XTAP_TAPCELL_ROW_50_493 VGND VPWR sky130_fd_sc_hd__tapvpwrvgnd_1
XFILLER_32_85 VPWR VGND VPWR VGND sky130_ef_sc_hd__decap_40_12
XFILLER_32_41 VPWR VGND VPWR VGND sky130_ef_sc_hd__decap_40_12
XFILLER_12_189 VGND VGND VPWR VPWR sky130_fd_sc_hd__fill_4
XFILLER_16_97 VPWR VGND VPWR VGND sky130_ef_sc_hd__decap_40_12
XFILLER_4_377 VPWR VGND VPWR VGND sky130_ef_sc_hd__decap_40_12
XFILLER_4_333 VPWR VGND VPWR VGND sky130_ef_sc_hd__decap_40_12
XFILLER_57_93 VPWR VGND VPWR VGND sky130_ef_sc_hd__decap_40_12
XFILLER_43_281 VGND VGND VPWR VPWR sky130_fd_sc_hd__fill_2
Xhold127 _530_/Q VGND VGND VPWR VPWR _403_/B sky130_fd_sc_hd__dlygate4sd3_1
Xhold138 _498_/Q VGND VGND VPWR VPWR _484_/A1 sky130_fd_sc_hd__dlygate4sd3_1
Xhold105 _487_/Q VGND VGND VPWR VPWR _434_/A sky130_fd_sc_hd__dlygate4sd3_1
XFILLER_7_193 VPWR VGND VPWR VGND sky130_ef_sc_hd__decap_40_12
Xhold116 _550_/Q VGND VGND VPWR VPWR _444_/A sky130_fd_sc_hd__dlygate4sd3_1
Xhold149 _459_/X VGND VGND VPWR VPWR _555_/D sky130_fd_sc_hd__dlygate4sd3_1
XFILLER_58_307 VGND VGND VPWR VPWR sky130_fd_sc_hd__fill_1
XTAP_TAPCELL_ROW_64_585 VGND VPWR sky130_fd_sc_hd__tapvpwrvgnd_1
XFILLER_26_248 VGND VGND VPWR VPWR sky130_fd_sc_hd__fill_4
XTAP_TAPCELL_ROW_64_596 VGND VPWR sky130_fd_sc_hd__tapvpwrvgnd_1
XFILLER_57_373 VPWR VGND VPWR VGND sky130_ef_sc_hd__decap_40_12
XFILLER_49_329 VGND VGND VPWR VPWR sky130_fd_sc_hd__fill_4
XFILLER_17_237 VPWR VGND VPWR VGND sky130_ef_sc_hd__decap_40_12
XFILLER_43_51 VGND VGND VPWR VPWR sky130_fd_sc_hd__fill_4
XFILLER_40_251 VGND VGND VPWR VPWR sky130_fd_sc_hd__fill_1
X_394_ _403_/D _394_/B VGND VGND VPWR VPWR _394_/Y sky130_fd_sc_hd__nor2_1
X_532_ _545_/CLK _532_/D VGND VGND VPWR VPWR _532_/Q sky130_fd_sc_hd__dfxtp_1
X_463_ _466_/B _466_/C _466_/D VGND VGND VPWR VPWR _465_/A sky130_fd_sc_hd__and3_1
XFILLER_40_295 VGND VGND VPWR VPWR sky130_fd_sc_hd__fill_1
XFILLER_4_141 VPWR VGND VPWR VGND sky130_ef_sc_hd__decap_40_12
XFILLER_0_391 VGND VGND VPWR VPWR sky130_fd_sc_hd__fill_1
XTAP_TAPCELL_ROW_18_265 VGND VPWR sky130_fd_sc_hd__tapvpwrvgnd_1
XTAP_TAPCELL_ROW_61_566 VGND VPWR sky130_fd_sc_hd__tapvpwrvgnd_1
XFILLER_58_137 VGND VGND VPWR VPWR sky130_fd_sc_hd__fill_2
XFILLER_54_321 VPWR VGND VPWR VGND sky130_ef_sc_hd__decap_40_12
XFILLER_48_29 VPWR VGND VPWR VGND sky130_ef_sc_hd__decap_40_12
XFILLER_54_365 VPWR VGND VPWR VGND sky130_ef_sc_hd__decap_40_12
XTAP_TAPCELL_ROW_1_144 VGND VPWR sky130_fd_sc_hd__tapvpwrvgnd_1
XFILLER_22_251 VGND VGND VPWR VPWR sky130_fd_sc_hd__fill_1
XTAP_TAPCELL_ROW_9_200 VGND VPWR sky130_fd_sc_hd__tapvpwrvgnd_1
XFILLER_49_137 VPWR VGND VPWR VGND sky130_ef_sc_hd__decap_40_12
XFILLER_1_111 VGND VGND VPWR VPWR sky130_fd_sc_hd__fill_1
XFILLER_8_3 VPWR VGND VPWR VGND sky130_ef_sc_hd__decap_40_12
XFILLER_57_181 VPWR VGND VPWR VGND sky130_ef_sc_hd__decap_40_12
X_515_ _523_/CLK _515_/D VGND VGND VPWR VPWR _515_/Q sky130_fd_sc_hd__dfxtp_1
XFILLER_60_357 VGND VGND VPWR VPWR sky130_fd_sc_hd__fill_4
XFILLER_54_83 VGND VGND VPWR VPWR sky130_fd_sc_hd__fill_1
X_377_ _386_/A _377_/B _377_/C VGND VGND VPWR VPWR _521_/D sky130_fd_sc_hd__and3_1
XPHY_EDGE_ROW_41_Left_106 VGND VGND VPWR VPWR sky130_fd_sc_hd__decap_3
XFILLER_9_277 VGND VGND VPWR VPWR sky130_fd_sc_hd__fill_2
XFILLER_13_273 VGND VGND VPWR VPWR sky130_fd_sc_hd__fill_4
XTAP_TAPCELL_ROW_15_246 VGND VPWR sky130_fd_sc_hd__tapvpwrvgnd_1
X_446_ _447_/B _434_/A _434_/B _447_/A VGND VGND VPWR VPWR _458_/C sky130_fd_sc_hd__o31a_2
XPHY_EDGE_ROW_50_Left_115 VGND VGND VPWR VPWR sky130_fd_sc_hd__decap_3
XFILLER_51_335 VGND VGND VPWR VPWR sky130_fd_sc_hd__fill_1
XFILLER_59_39 VPWR VGND VPWR VGND sky130_ef_sc_hd__decap_40_12
XFILLER_54_195 VGND VGND VPWR VPWR sky130_fd_sc_hd__fill_1
XFILLER_42_346 VGND VGND VPWR VPWR sky130_fd_sc_hd__fill_4
X_300_ _245_/Y _306_/B _485_/A VGND VGND VPWR VPWR _300_/X sky130_fd_sc_hd__a21o_1
XFILLER_27_398 VGND VGND VPWR VPWR sky130_fd_sc_hd__fill_1
XFILLER_10_221 VPWR VGND VPWR VGND sky130_ef_sc_hd__decap_40_12
XTAP_TAPCELL_ROW_12_227 VGND VPWR sky130_fd_sc_hd__tapvpwrvgnd_1
XFILLER_24_53 VPWR VGND VPWR VGND sky130_ef_sc_hd__decap_40_12
XFILLER_24_97 VPWR VGND VPWR VGND sky130_ef_sc_hd__decap_40_12
XFILLER_40_85 VPWR VGND VPWR VGND sky130_ef_sc_hd__decap_40_12
XFILLER_40_41 VPWR VGND VPWR VGND sky130_ef_sc_hd__decap_40_12
XFILLER_10_265 VPWR VGND VPWR VGND sky130_ef_sc_hd__decap_40_12
XTAP_TAPCELL_ROW_20_282 VGND VPWR sky130_fd_sc_hd__tapvpwrvgnd_1
XFILLER_60_165 VPWR VGND VPWR VGND sky130_ef_sc_hd__decap_40_12
XFILLER_60_121 VPWR VGND VPWR VGND sky130_ef_sc_hd__decap_40_12
XFILLER_1_57 VPWR VGND VPWR VGND sky130_ef_sc_hd__decap_40_12
XFILLER_18_365 VPWR VGND VPWR VGND sky130_ef_sc_hd__decap_40_12
XFILLER_18_398 VGND VGND VPWR VPWR sky130_fd_sc_hd__fill_8
XFILLER_60_3 VPWR VGND VPWR VGND sky130_ef_sc_hd__decap_40_12
XFILLER_41_390 VGND VGND VPWR VPWR sky130_fd_sc_hd__fill_2
X_429_ _485_/A hold1/X VGND VGND VPWR VPWR hold2/A sky130_fd_sc_hd__or2_1
XANTENNA__300__B1 _485_/A VGND VGND VPWR VPWR sky130_fd_sc_hd__diode_2
XFILLER_56_405 VGND VGND VPWR VPWR sky130_fd_sc_hd__fill_2
XTAP_TAPCELL_ROW_26_319 VGND VPWR sky130_fd_sc_hd__tapvpwrvgnd_1
Xinput1 sw_0 VGND VGND VPWR VPWR input1/X sky130_fd_sc_hd__clkbuf_1
XFILLER_51_165 VGND VGND VPWR VPWR sky130_fd_sc_hd__fill_2
XFILLER_24_368 VGND VGND VPWR VPWR sky130_fd_sc_hd__fill_1
XFILLER_3_217 VGND VGND VPWR VPWR sky130_fd_sc_hd__fill_4
XFILLER_59_221 VGND VGND VPWR VPWR sky130_fd_sc_hd__fill_2
XFILLER_47_405 VGND VGND VPWR VPWR sky130_fd_sc_hd__fill_2
XFILLER_10_77 VGND VGND VPWR VPWR sky130_fd_sc_hd__fill_4
XFILLER_42_121 VPWR VGND VPWR VGND sky130_ef_sc_hd__decap_40_12
XFILLER_15_335 VGND VGND VPWR VPWR sky130_fd_sc_hd__fill_1
XFILLER_51_51 VGND VGND VPWR VPWR sky130_fd_sc_hd__fill_4
XFILLER_42_165 VGND VGND VPWR VPWR sky130_fd_sc_hd__fill_8
XTAP_TAPCELL_ROW_48_477 VGND VPWR sky130_fd_sc_hd__tapvpwrvgnd_1
XFILLER_38_405 VGND VGND VPWR VPWR sky130_fd_sc_hd__fill_2
XFILLER_18_195 VGND VGND VPWR VPWR sky130_fd_sc_hd__fill_1
XFILLER_21_327 VGND VGND VPWR VPWR sky130_fd_sc_hd__fill_8
XTAP_TAPCELL_ROW_31_355 VGND VPWR sky130_fd_sc_hd__tapvpwrvgnd_1
XFILLER_56_29 VPWR VGND VPWR VGND sky130_ef_sc_hd__decap_40_12
XFILLER_0_209 VPWR VGND VPWR VGND sky130_ef_sc_hd__decap_40_12
XTAP_TAPCELL_ROW_39_411 VGND VPWR sky130_fd_sc_hd__tapvpwrvgnd_1
XFILLER_24_121 VPWR VGND VPWR VGND sky130_ef_sc_hd__decap_40_12
XFILLER_8_309 VPWR VGND VPWR VGND sky130_ef_sc_hd__decap_40_12
XFILLER_12_305 VGND VGND VPWR VPWR sky130_fd_sc_hd__fill_2
XFILLER_24_165 VPWR VGND VPWR VGND sky130_ef_sc_hd__decap_40_12
XFILLER_47_279 VGND VGND VPWR VPWR sky130_fd_sc_hd__fill_1
XFILLER_62_249 VGND VGND VPWR VPWR sky130_fd_sc_hd__fill_2
XTAP_TAPCELL_ROW_45_458 VGND VPWR sky130_fd_sc_hd__tapvpwrvgnd_1
XFILLER_15_165 VGND VGND VPWR VPWR sky130_fd_sc_hd__fill_2
XFILLER_62_83 VGND VGND VPWR VPWR sky130_fd_sc_hd__fill_1
XFILLER_11_393 VPWR VGND VPWR VGND sky130_ef_sc_hd__decap_40_12
XFILLER_23_3 VPWR VGND VPWR VGND sky130_ef_sc_hd__decap_40_12
XFILLER_53_249 VPWR VGND VPWR VGND sky130_ef_sc_hd__decap_40_12
XFILLER_53_205 VPWR VGND VPWR VGND sky130_ef_sc_hd__decap_40_12
XFILLER_46_290 VGND VGND VPWR VPWR sky130_fd_sc_hd__fill_1
XFILLER_38_279 VGND VGND VPWR VPWR sky130_fd_sc_hd__fill_1
XFILLER_61_293 VPWR VGND VPWR VGND sky130_ef_sc_hd__decap_40_12
XFILLER_21_113 VPWR VGND VPWR VGND sky130_ef_sc_hd__decap_40_12
XFILLER_16_65 VPWR VGND VPWR VGND sky130_ef_sc_hd__decap_40_12
XFILLER_32_97 VPWR VGND VPWR VGND sky130_ef_sc_hd__decap_40_12
XFILLER_32_53 VPWR VGND VPWR VGND sky130_ef_sc_hd__decap_40_12
XFILLER_4_301 VGND VGND VPWR VPWR sky130_fd_sc_hd__fill_4
XFILLER_8_139 VGND VGND VPWR VPWR sky130_fd_sc_hd__fill_1
XFILLER_4_389 VPWR VGND VPWR VGND sky130_ef_sc_hd__decap_40_12
XFILLER_4_345 VPWR VGND VPWR VGND sky130_ef_sc_hd__decap_40_12
Xhold128 _401_/Y VGND VGND VPWR VPWR _402_/B sky130_fd_sc_hd__dlygate4sd3_1
Xhold106 _338_/X VGND VGND VPWR VPWR _504_/D sky130_fd_sc_hd__dlygate4sd3_1
Xhold139 _484_/X VGND VGND VPWR VPWR _485_/C sky130_fd_sc_hd__dlygate4sd3_1
XFILLER_7_161 VGND VGND VPWR VPWR sky130_fd_sc_hd__fill_4
XPHY_EDGE_ROW_9_Right_9 VGND VGND VPWR VPWR sky130_fd_sc_hd__decap_3
Xhold117 _285_/A VGND VGND VPWR VPWR _294_/A3 sky130_fd_sc_hd__dlygate4sd3_1
XTAP_TAPCELL_ROW_64_597 VGND VPWR sky130_fd_sc_hd__tapvpwrvgnd_1
XTAP_TAPCELL_ROW_64_586 VGND VPWR sky130_fd_sc_hd__tapvpwrvgnd_1
XFILLER_5_109 VGND VGND VPWR VPWR sky130_fd_sc_hd__fill_2
XFILLER_1_337 VPWR VGND VPWR VGND sky130_ef_sc_hd__decap_40_12
XFILLER_57_385 VGND VGND VPWR VPWR sky130_fd_sc_hd__fill_4
X_531_ _545_/CLK _531_/D VGND VGND VPWR VPWR _531_/Q sky130_fd_sc_hd__dfxtp_1
XFILLER_17_205 VPWR VGND VPWR VGND sky130_ef_sc_hd__decap_40_12
XFILLER_17_249 VPWR VGND VPWR VGND sky130_ef_sc_hd__decap_40_12
X_393_ hold87/X _389_/X _428_/A VGND VGND VPWR VPWR _393_/Y sky130_fd_sc_hd__o21ai_1
X_462_ _462_/A _462_/B VGND VGND VPWR VPWR _462_/Y sky130_fd_sc_hd__nor2_1
XFILLER_4_153 VPWR VGND VPWR VGND sky130_ef_sc_hd__decap_40_12
XFILLER_4_197 VPWR VGND VPWR VGND sky130_ef_sc_hd__decap_40_12
XFILLER_63_333 VGND VGND VPWR VPWR sky130_fd_sc_hd__fill_2
XFILLER_48_363 VGND VGND VPWR VPWR sky130_fd_sc_hd__fill_1
XTAP_TAPCELL_ROW_18_266 VGND VPWR sky130_fd_sc_hd__tapvpwrvgnd_1
XTAP_TAPCELL_ROW_61_567 VGND VPWR sky130_fd_sc_hd__tapvpwrvgnd_1
XFILLER_64_29 VPWR VGND VPWR VGND sky130_ef_sc_hd__decap_40_12
XFILLER_54_333 VPWR VGND VPWR VGND sky130_ef_sc_hd__decap_40_12
XFILLER_39_330 VGND VGND VPWR VPWR sky130_fd_sc_hd__fill_4
XTAP_TAPCELL_ROW_1_145 VGND VPWR sky130_fd_sc_hd__tapvpwrvgnd_1
XFILLER_54_377 VPWR VGND VPWR VGND sky130_ef_sc_hd__decap_40_12
XTAP_TAPCELL_ROW_52_501 VGND VPWR sky130_fd_sc_hd__tapvpwrvgnd_1
Xfanout12 _337_/B VGND VGND VPWR VPWR _273_/A sky130_fd_sc_hd__buf_4
XTAP_TAPCELL_ROW_9_201 VGND VPWR sky130_fd_sc_hd__tapvpwrvgnd_1
XFILLER_13_55 VGND VGND VPWR VPWR sky130_fd_sc_hd__fill_1
XFILLER_49_149 VPWR VGND VPWR VGND sky130_ef_sc_hd__decap_40_12
XFILLER_49_105 VGND VGND VPWR VPWR sky130_fd_sc_hd__fill_4
XFILLER_38_41 VPWR VGND VPWR VGND sky130_ef_sc_hd__decap_40_12
XFILLER_1_167 VGND VGND VPWR VPWR sky130_fd_sc_hd__fill_1
XFILLER_57_193 VPWR VGND VPWR VGND sky130_ef_sc_hd__decap_40_12
X_514_ _523_/CLK _514_/D VGND VGND VPWR VPWR _514_/Q sky130_fd_sc_hd__dfxtp_1
XFILLER_38_85 VPWR VGND VPWR VGND sky130_ef_sc_hd__decap_40_12
X_376_ _379_/B _376_/B VGND VGND VPWR VPWR _377_/C sky130_fd_sc_hd__nand2_1
XFILLER_9_223 VGND VGND VPWR VPWR sky130_fd_sc_hd__fill_1
XTAP_TAPCELL_ROW_15_247 VGND VPWR sky130_fd_sc_hd__tapvpwrvgnd_1
X_445_ _445_/A _445_/B VGND VGND VPWR VPWR _445_/X sky130_fd_sc_hd__and2_1
XFILLER_48_193 VGND VGND VPWR VPWR sky130_fd_sc_hd__fill_2
XFILLER_36_311 VGND VGND VPWR VPWR sky130_fd_sc_hd__fill_1
XANTENNA_input2_A uart_rxd VGND VGND VPWR VPWR sky130_fd_sc_hd__diode_2
XFILLER_54_141 VPWR VGND VPWR VGND sky130_ef_sc_hd__decap_40_12
XFILLER_42_303 VGND VGND VPWR VPWR sky130_fd_sc_hd__fill_4
XFILLER_39_171 VGND VGND VPWR VPWR sky130_fd_sc_hd__fill_1
XFILLER_27_300 VGND VGND VPWR VPWR sky130_fd_sc_hd__fill_2
XFILLER_42_358 VGND VGND VPWR VPWR sky130_fd_sc_hd__fill_4
XFILLER_10_233 VPWR VGND VPWR VGND sky130_ef_sc_hd__decap_40_12
XFILLER_10_277 VPWR VGND VPWR VGND sky130_ef_sc_hd__decap_40_12
XFILLER_24_65 VPWR VGND VPWR VGND sky130_ef_sc_hd__decap_40_12
XFILLER_40_97 VPWR VGND VPWR VGND sky130_ef_sc_hd__decap_40_12
XFILLER_40_53 VPWR VGND VPWR VGND sky130_ef_sc_hd__decap_40_12
XTAP_TAPCELL_ROW_20_283 VGND VPWR sky130_fd_sc_hd__tapvpwrvgnd_1
XFILLER_49_51 VGND VGND VPWR VPWR sky130_fd_sc_hd__fill_4
XFILLER_1_69 VPWR VGND VPWR VGND sky130_ef_sc_hd__decap_40_12
XFILLER_60_177 VPWR VGND VPWR VGND sky130_ef_sc_hd__decap_40_12
XFILLER_60_133 VGND VGND VPWR VPWR sky130_fd_sc_hd__fill_4
X_428_ _428_/A _428_/B _428_/C VGND VGND VPWR VPWR _428_/X sky130_fd_sc_hd__and3_1
XFILLER_18_377 VGND VGND VPWR VPWR sky130_fd_sc_hd__fill_4
XPHY_EDGE_ROW_23_Left_88 VGND VGND VPWR VPWR sky130_fd_sc_hd__decap_3
XFILLER_53_3 VPWR VGND VPWR VGND sky130_ef_sc_hd__decap_40_12
X_359_ hold57/X _356_/Y _357_/X _374_/C VGND VGND VPWR VPWR _513_/D sky130_fd_sc_hd__o211a_1
XANTENNA_clkbuf_3_0__f_clk_A clkbuf_0_clk/X VGND VGND VPWR VPWR sky130_fd_sc_hd__diode_2
XFILLER_5_281 VPWR VGND VPWR VGND sky130_ef_sc_hd__decap_40_12
XFILLER_51_111 VGND VGND VPWR VPWR sky130_fd_sc_hd__fill_1
XFILLER_36_141 VPWR VGND VPWR VGND sky130_ef_sc_hd__decap_40_12
Xinput2 uart_rxd VGND VGND VPWR VPWR _430_/B sky130_fd_sc_hd__buf_1
XFILLER_24_336 VGND VGND VPWR VPWR sky130_fd_sc_hd__fill_2
XTAP_TAPCELL_ROW_34_375 VGND VPWR sky130_fd_sc_hd__tapvpwrvgnd_1
XFILLER_59_277 VGND VGND VPWR VPWR sky130_fd_sc_hd__fill_2
XFILLER_42_133 VGND VGND VPWR VPWR sky130_fd_sc_hd__fill_4
XFILLER_2_251 VGND VGND VPWR VPWR sky130_fd_sc_hd__fill_1
XTAP_TAPCELL_ROW_48_478 VGND VPWR sky130_fd_sc_hd__tapvpwrvgnd_1
XFILLER_33_111 VGND VGND VPWR VPWR sky130_fd_sc_hd__fill_1
XFILLER_18_141 VPWR VGND VPWR VGND sky130_ef_sc_hd__decap_40_12
XFILLER_33_177 VGND VGND VPWR VPWR sky130_fd_sc_hd__fill_1
XTAP_TAPCELL_ROW_31_356 VGND VPWR sky130_fd_sc_hd__tapvpwrvgnd_1
XTAP_TAPCELL_ROW_39_412 VGND VPWR sky130_fd_sc_hd__tapvpwrvgnd_1
XFILLER_24_133 VGND VGND VPWR VPWR sky130_fd_sc_hd__fill_4
XFILLER_24_177 VPWR VGND VPWR VGND sky130_ef_sc_hd__decap_40_12
XFILLER_21_55 VGND VGND VPWR VPWR sky130_fd_sc_hd__fill_1
XFILLER_47_225 VPWR VGND VPWR VGND sky130_ef_sc_hd__decap_40_12
XFILLER_46_85 VPWR VGND VPWR VGND sky130_ef_sc_hd__decap_40_12
XFILLER_46_41 VPWR VGND VPWR VGND sky130_ef_sc_hd__decap_40_12
XFILLER_15_111 VGND VGND VPWR VPWR sky130_fd_sc_hd__fill_1
XFILLER_7_57 VPWR VGND VPWR VGND sky130_ef_sc_hd__decap_40_12
XFILLER_11_361 VPWR VGND VPWR VGND sky130_ef_sc_hd__decap_40_12
XFILLER_16_3 VPWR VGND VPWR VGND sky130_ef_sc_hd__decap_40_12
XFILLER_61_261 VPWR VGND VPWR VGND sky130_ef_sc_hd__decap_40_12
XFILLER_53_217 VGND VGND VPWR VPWR sky130_fd_sc_hd__fill_4
XPHY_EDGE_ROW_26_Left_91 VGND VGND VPWR VPWR sky130_fd_sc_hd__decap_3
XFILLER_21_125 VPWR VGND VPWR VGND sky130_ef_sc_hd__decap_40_12
XFILLER_21_169 VPWR VGND VPWR VGND sky130_ef_sc_hd__decap_40_12
XPHY_EDGE_ROW_10_Left_75 VGND VGND VPWR VPWR sky130_fd_sc_hd__decap_3
XFILLER_44_228 VPWR VGND VPWR VGND sky130_ef_sc_hd__decap_40_12
XFILLER_16_77 VGND VGND VPWR VPWR sky130_fd_sc_hd__fill_4
XFILLER_32_65 VPWR VGND VPWR VGND sky130_ef_sc_hd__decap_40_12
XFILLER_4_357 VGND VGND VPWR VPWR sky130_fd_sc_hd__fill_4
XFILLER_57_51 VGND VGND VPWR VPWR sky130_fd_sc_hd__fill_4
XFILLER_50_209 VPWR VGND VPWR VGND sky130_ef_sc_hd__decap_40_12
Xhold107 _505_/Q VGND VGND VPWR VPWR _319_/A1 sky130_fd_sc_hd__dlygate4sd3_1
Xhold129 _402_/Y VGND VGND VPWR VPWR _530_/D sky130_fd_sc_hd__dlygate4sd3_1
Xhold118 _294_/X VGND VGND VPWR VPWR _489_/D sky130_fd_sc_hd__dlygate4sd3_1
XFILLER_58_309 VPWR VGND VPWR VGND sky130_ef_sc_hd__decap_40_12
XTAP_TAPCELL_ROW_64_598 VGND VPWR sky130_fd_sc_hd__tapvpwrvgnd_1
XTAP_TAPCELL_ROW_64_587 VGND VPWR sky130_fd_sc_hd__tapvpwrvgnd_1
XFILLER_34_294 VGND VGND VPWR VPWR sky130_fd_sc_hd__fill_4
XFILLER_1_349 VPWR VGND VPWR VGND sky130_ef_sc_hd__decap_40_12
XFILLER_1_305 VPWR VGND VPWR VGND sky130_ef_sc_hd__decap_40_12
X_530_ _545_/CLK _530_/D VGND VGND VPWR VPWR _530_/Q sky130_fd_sc_hd__dfxtp_1
XTAP_TAPCELL_ROW_4_165 VGND VPWR sky130_fd_sc_hd__tapvpwrvgnd_1
XFILLER_17_217 VGND VGND VPWR VPWR sky130_fd_sc_hd__fill_4
X_461_ _466_/C _466_/D _481_/A VGND VGND VPWR VPWR _461_/Y sky130_fd_sc_hd__o21ai_1
X_392_ _390_/B _390_/C _390_/D _390_/A hold87/X VGND VGND VPWR VPWR _403_/D sky130_fd_sc_hd__o311a_2
XFILLER_9_405 VGND VGND VPWR VPWR sky130_fd_sc_hd__fill_2
XFILLER_4_165 VPWR VGND VPWR VGND sky130_ef_sc_hd__decap_40_12
XFILLER_4_121 VPWR VGND VPWR VGND sky130_ef_sc_hd__decap_40_12
XFILLER_0_393 VPWR VGND VPWR VGND sky130_ef_sc_hd__decap_40_12
XFILLER_63_389 VGND VGND VPWR VPWR sky130_fd_sc_hd__fill_2
XTAP_TAPCELL_ROW_61_568 VGND VPWR sky130_fd_sc_hd__tapvpwrvgnd_1
XTAP_TAPCELL_ROW_18_267 VGND VPWR sky130_fd_sc_hd__tapvpwrvgnd_1
XFILLER_58_139 VGND VGND VPWR VPWR sky130_fd_sc_hd__fill_1
XFILLER_54_345 VPWR VGND VPWR VGND sky130_ef_sc_hd__decap_40_12
XFILLER_54_301 VGND VGND VPWR VPWR sky130_fd_sc_hd__fill_4
XTAP_TAPCELL_ROW_1_146 VGND VPWR sky130_fd_sc_hd__tapvpwrvgnd_1
XFILLER_14_209 VPWR VGND VPWR VGND sky130_ef_sc_hd__decap_40_12
XFILLER_54_389 VPWR VGND VPWR VGND sky130_ef_sc_hd__decap_40_12
XTAP_TAPCELL_ROW_52_502 VGND VPWR sky130_fd_sc_hd__tapvpwrvgnd_1
Xfanout13 input1/X VGND VGND VPWR VPWR _337_/B sky130_fd_sc_hd__buf_4
XFILLER_1_113 VPWR VGND VPWR VGND sky130_ef_sc_hd__decap_40_12
XTAP_TAPCELL_ROW_9_202 VGND VPWR sky130_fd_sc_hd__tapvpwrvgnd_1
XFILLER_64_109 VGND VGND VPWR VPWR sky130_fd_sc_hd__fill_2
XFILLER_57_161 VGND VGND VPWR VPWR sky130_fd_sc_hd__fill_4
XFILLER_38_97 VPWR VGND VPWR VGND sky130_ef_sc_hd__decap_40_12
XFILLER_38_53 VPWR VGND VPWR VGND sky130_ef_sc_hd__decap_40_12
XFILLER_54_85 VPWR VGND VPWR VGND sky130_ef_sc_hd__decap_40_12
XFILLER_54_41 VPWR VGND VPWR VGND sky130_ef_sc_hd__decap_40_12
XFILLER_45_389 VGND VGND VPWR VPWR sky130_fd_sc_hd__fill_2
X_513_ _523_/CLK _513_/D VGND VGND VPWR VPWR _513_/Q sky130_fd_sc_hd__dfxtp_1
XANTENNA__388__C1 _337_/B VGND VGND VPWR VPWR sky130_fd_sc_hd__diode_2
XTAP_TAPCELL_ROW_15_248 VGND VPWR sky130_fd_sc_hd__tapvpwrvgnd_1
X_444_ _444_/A _444_/B VGND VGND VPWR VPWR _445_/B sky130_fd_sc_hd__xor2_1
X_375_ _379_/B _376_/B VGND VGND VPWR VPWR _377_/B sky130_fd_sc_hd__or2_1
XFILLER_9_279 VGND VGND VPWR VPWR sky130_fd_sc_hd__fill_1
XFILLER_55_109 VGND VGND VPWR VPWR sky130_fd_sc_hd__fill_2
XFILLER_51_337 VPWR VGND VPWR VGND sky130_ef_sc_hd__decap_40_12
XFILLER_46_109 VPWR VGND VPWR VGND sky130_ef_sc_hd__decap_40_12
XFILLER_39_161 VGND VGND VPWR VPWR sky130_fd_sc_hd__fill_4
XFILLER_54_197 VPWR VGND VPWR VGND sky130_ef_sc_hd__decap_40_12
XFILLER_54_153 VPWR VGND VPWR VGND sky130_ef_sc_hd__decap_40_12
XFILLER_27_323 VPWR VGND VPWR VGND sky130_ef_sc_hd__decap_40_12
XFILLER_6_249 VGND VGND VPWR VPWR sky130_fd_sc_hd__fill_2
XFILLER_10_245 VGND VGND VPWR VPWR sky130_fd_sc_hd__fill_4
XFILLER_10_289 VPWR VGND VPWR VGND sky130_ef_sc_hd__decap_40_12
XFILLER_24_77 VGND VGND VPWR VPWR sky130_fd_sc_hd__fill_4
XFILLER_40_65 VPWR VGND VPWR VGND sky130_ef_sc_hd__decap_40_12
XFILLER_37_109 VGND VGND VPWR VPWR sky130_fd_sc_hd__fill_2
XFILLER_1_15 VPWR VGND VPWR VGND sky130_ef_sc_hd__decap_40_12
XFILLER_60_189 VGND VGND VPWR VPWR sky130_fd_sc_hd__fill_4
X_427_ _427_/A _427_/B _427_/C VGND VGND VPWR VPWR _427_/Y sky130_fd_sc_hd__nand3_1
XFILLER_33_326 VGND VGND VPWR VPWR sky130_fd_sc_hd__fill_2
X_358_ _358_/A _485_/A VGND VGND VPWR VPWR _374_/C sky130_fd_sc_hd__nor2_2
X_289_ _390_/C _337_/B _289_/C VGND VGND VPWR VPWR _289_/X sky130_fd_sc_hd__and3_1
XFILLER_46_3 VPWR VGND VPWR VGND sky130_ef_sc_hd__decap_40_12
XFILLER_28_109 VPWR VGND VPWR VGND sky130_ef_sc_hd__decap_40_12
XFILLER_5_293 VPWR VGND VPWR VGND sky130_ef_sc_hd__decap_40_12
XPHY_EDGE_ROW_18_Right_18 VGND VGND VPWR VPWR sky130_fd_sc_hd__decap_3
XFILLER_36_153 VGND VGND VPWR VPWR sky130_fd_sc_hd__fill_4
XPHY_EDGE_ROW_27_Right_27 VGND VGND VPWR VPWR sky130_fd_sc_hd__decap_3
XFILLER_51_167 VGND VGND VPWR VPWR sky130_fd_sc_hd__fill_1
XTAP_TAPCELL_ROW_34_376 VGND VPWR sky130_fd_sc_hd__tapvpwrvgnd_1
XPHY_EDGE_ROW_36_Right_36 VGND VGND VPWR VPWR sky130_fd_sc_hd__decap_3
XFILLER_59_223 VGND VGND VPWR VPWR sky130_fd_sc_hd__fill_1
XFILLER_19_55 VGND VGND VPWR VPWR sky130_fd_sc_hd__fill_1
XFILLER_19_109 VGND VGND VPWR VPWR sky130_fd_sc_hd__fill_2
XPHY_EDGE_ROW_45_Right_45 VGND VGND VPWR VPWR sky130_fd_sc_hd__decap_3
XFILLER_15_337 VPWR VGND VPWR VGND sky130_ef_sc_hd__decap_40_12
XPHY_EDGE_ROW_54_Right_54 VGND VGND VPWR VPWR sky130_fd_sc_hd__decap_3
XPHY_EDGE_ROW_63_Right_63 VGND VGND VPWR VPWR sky130_fd_sc_hd__decap_3
XTAP_TAPCELL_ROW_48_479 VGND VPWR sky130_fd_sc_hd__tapvpwrvgnd_1
XPHY_EDGE_ROW_38_Left_103 VGND VGND VPWR VPWR sky130_fd_sc_hd__decap_3
XFILLER_18_153 VPWR VGND VPWR VGND sky130_ef_sc_hd__decap_40_12
XFILLER_18_197 VPWR VGND VPWR VGND sky130_ef_sc_hd__decap_40_12
XTAP_TAPCELL_ROW_31_357 VGND VPWR sky130_fd_sc_hd__tapvpwrvgnd_1
XPHY_EDGE_ROW_47_Left_112 VGND VGND VPWR VPWR sky130_fd_sc_hd__decap_3
XTAP_TAPCELL_ROW_39_413 VGND VPWR sky130_fd_sc_hd__tapvpwrvgnd_1
XFILLER_64_281 VPWR VGND VPWR VGND sky130_ef_sc_hd__decap_40_12
XPHY_EDGE_ROW_56_Left_121 VGND VGND VPWR VPWR sky130_fd_sc_hd__decap_3
XFILLER_12_307 VGND VGND VPWR VPWR sky130_fd_sc_hd__fill_1
XFILLER_24_189 VGND VGND VPWR VPWR sky130_fd_sc_hd__fill_4
XFILLER_20_362 VGND VGND VPWR VPWR sky130_fd_sc_hd__fill_2
XFILLER_55_281 VPWR VGND VPWR VGND sky130_ef_sc_hd__decap_40_12
XFILLER_47_237 VPWR VGND VPWR VGND sky130_ef_sc_hd__decap_40_12
XFILLER_46_97 VPWR VGND VPWR VGND sky130_ef_sc_hd__decap_40_12
XFILLER_46_53 VPWR VGND VPWR VGND sky130_ef_sc_hd__decap_40_12
XFILLER_62_85 VPWR VGND VPWR VGND sky130_ef_sc_hd__decap_40_12
XFILLER_62_41 VPWR VGND VPWR VGND sky130_ef_sc_hd__decap_40_12
XFILLER_30_137 VGND VGND VPWR VPWR sky130_fd_sc_hd__fill_2
XFILLER_7_333 VGND VGND VPWR VPWR sky130_fd_sc_hd__fill_2
XFILLER_11_373 VPWR VGND VPWR VGND sky130_ef_sc_hd__decap_40_12
XFILLER_15_167 VGND VGND VPWR VPWR sky130_fd_sc_hd__fill_1
XFILLER_7_69 VPWR VGND VPWR VGND sky130_ef_sc_hd__decap_40_12
XFILLER_38_248 VGND VGND VPWR VPWR sky130_fd_sc_hd__fill_4
XANTENNA__430__A _485_/A VGND VGND VPWR VPWR sky130_fd_sc_hd__diode_2
XFILLER_61_273 VGND VGND VPWR VPWR sky130_fd_sc_hd__fill_4
XFILLER_21_137 VPWR VGND VPWR VGND sky130_ef_sc_hd__decap_40_12
XFILLER_37_281 VGND VGND VPWR VPWR sky130_fd_sc_hd__fill_2
XFILLER_52_251 VGND VGND VPWR VPWR sky130_fd_sc_hd__fill_1
XPHY_EDGE_ROW_0_Right_0 VGND VGND VPWR VPWR sky130_fd_sc_hd__decap_3
XFILLER_12_137 VGND VGND VPWR VPWR sky130_fd_sc_hd__fill_2
XFILLER_32_77 VGND VGND VPWR VPWR sky130_fd_sc_hd__fill_4
XFILLER_43_251 VPWR VGND VPWR VGND sky130_ef_sc_hd__decap_40_12
XFILLER_28_270 VGND VGND VPWR VPWR sky130_fd_sc_hd__fill_2
XTAP_TAPCELL_ROW_41_430 VGND VPWR sky130_fd_sc_hd__tapvpwrvgnd_1
Xhold108 _319_/X VGND VGND VPWR VPWR _498_/D sky130_fd_sc_hd__dlygate4sd3_1
XFILLER_11_181 VPWR VGND VPWR VGND sky130_ef_sc_hd__decap_40_12
Xhold119 _534_/Q VGND VGND VPWR VPWR _412_/A sky130_fd_sc_hd__dlygate4sd3_1
XFILLER_3_391 VGND VGND VPWR VPWR sky130_fd_sc_hd__fill_1
XTAP_TAPCELL_ROW_64_588 VGND VPWR sky130_fd_sc_hd__tapvpwrvgnd_1
XTAP_TAPCELL_ROW_4_166 VGND VPWR sky130_fd_sc_hd__tapvpwrvgnd_1
XFILLER_1_317 VPWR VGND VPWR VGND sky130_ef_sc_hd__decap_40_12
XTAP_TAPCELL_ROW_55_522 VGND VPWR sky130_fd_sc_hd__tapvpwrvgnd_1
X_391_ _389_/X _391_/B _428_/A VGND VGND VPWR VPWR _526_/D sky130_fd_sc_hd__and3b_1
XFILLER_27_55 VGND VGND VPWR VPWR sky130_fd_sc_hd__fill_1
XFILLER_25_251 VGND VGND VPWR VPWR sky130_fd_sc_hd__fill_4
X_460_ _466_/C _466_/D VGND VGND VPWR VPWR _462_/A sky130_fd_sc_hd__and2_1
XFILLER_40_276 VGND VGND VPWR VPWR sky130_fd_sc_hd__fill_1
XFILLER_40_265 VGND VGND VPWR VPWR sky130_fd_sc_hd__fill_2
XFILLER_4_177 VPWR VGND VPWR VGND sky130_ef_sc_hd__decap_40_12
XFILLER_4_133 VGND VGND VPWR VPWR sky130_fd_sc_hd__fill_4
XFILLER_4_15 VPWR VGND VPWR VGND sky130_ef_sc_hd__decap_40_12
XFILLER_63_335 VGND VGND VPWR VPWR sky130_fd_sc_hd__fill_1
XFILLER_48_365 VPWR VGND VPWR VGND sky130_ef_sc_hd__decap_40_12
XFILLER_48_321 VPWR VGND VPWR VGND sky130_ef_sc_hd__decap_40_12
XFILLER_0_361 VGND VGND VPWR VPWR sky130_fd_sc_hd__fill_2
XTAP_TAPCELL_ROW_61_569 VGND VPWR sky130_fd_sc_hd__tapvpwrvgnd_1
XFILLER_31_221 VGND VGND VPWR VPWR sky130_fd_sc_hd__fill_2
XFILLER_16_251 VGND VGND VPWR VPWR sky130_fd_sc_hd__fill_1
XTAP_TAPCELL_ROW_18_268 VGND VPWR sky130_fd_sc_hd__tapvpwrvgnd_1
XFILLER_39_321 VGND VGND VPWR VPWR sky130_fd_sc_hd__fill_1
XFILLER_54_357 VGND VGND VPWR VPWR sky130_fd_sc_hd__fill_4
XTAP_TAPCELL_ROW_52_503 VGND VPWR sky130_fd_sc_hd__tapvpwrvgnd_1
XTAP_TAPCELL_ROW_1_147 VGND VPWR sky130_fd_sc_hd__tapvpwrvgnd_1
XFILLER_10_405 VGND VGND VPWR VPWR sky130_fd_sc_hd__fill_2
XFILLER_13_57 VPWR VGND VPWR VGND sky130_ef_sc_hd__decap_40_12
XFILLER_22_221 VPWR VGND VPWR VGND sky130_ef_sc_hd__decap_40_12
XFILLER_1_125 VPWR VGND VPWR VGND sky130_ef_sc_hd__decap_40_12
XTAP_TAPCELL_ROW_9_203 VGND VPWR sky130_fd_sc_hd__tapvpwrvgnd_1
XFILLER_38_65 VPWR VGND VPWR VGND sky130_ef_sc_hd__decap_40_12
XFILLER_1_169 VPWR VGND VPWR VGND sky130_ef_sc_hd__decap_40_12
XFILLER_60_305 VGND VGND VPWR VPWR sky130_fd_sc_hd__fill_2
XFILLER_54_97 VPWR VGND VPWR VGND sky130_ef_sc_hd__decap_40_12
XFILLER_54_53 VPWR VGND VPWR VGND sky130_ef_sc_hd__decap_40_12
X_374_ _374_/A _374_/B _374_/C VGND VGND VPWR VPWR _386_/A sky130_fd_sc_hd__and3_1
X_512_ _523_/CLK _512_/D VGND VGND VPWR VPWR _512_/Q sky130_fd_sc_hd__dfxtp_1
XFILLER_9_225 VPWR VGND VPWR VGND sky130_ef_sc_hd__decap_40_12
XFILLER_13_221 VGND VGND VPWR VPWR sky130_fd_sc_hd__fill_2
X_443_ _444_/B _445_/A _443_/C VGND VGND VPWR VPWR _549_/D sky130_fd_sc_hd__and3b_1
XANTENNA__312__B1 _485_/A VGND VGND VPWR VPWR sky130_fd_sc_hd__diode_2
XFILLER_63_165 VGND VGND VPWR VPWR sky130_fd_sc_hd__fill_2
XFILLER_51_305 VPWR VGND VPWR VGND sky130_ef_sc_hd__decap_40_12
XFILLER_48_195 VGND VGND VPWR VPWR sky130_fd_sc_hd__fill_1
XFILLER_36_302 VGND VGND VPWR VPWR sky130_fd_sc_hd__fill_1
XFILLER_0_191 VGND VGND VPWR VPWR sky130_fd_sc_hd__fill_1
XFILLER_51_349 VPWR VGND VPWR VGND sky130_ef_sc_hd__decap_40_12
XFILLER_59_405 VGND VGND VPWR VPWR sky130_fd_sc_hd__fill_2
XFILLER_54_121 VPWR VGND VPWR VGND sky130_ef_sc_hd__decap_40_12
XFILLER_27_335 VGND VGND VPWR VPWR sky130_fd_sc_hd__fill_1
XFILLER_54_165 VPWR VGND VPWR VGND sky130_ef_sc_hd__decap_40_12
XTAP_TAPCELL_ROW_37_396 VGND VPWR sky130_fd_sc_hd__tapvpwrvgnd_1
XFILLER_27_357 VGND VGND VPWR VPWR sky130_fd_sc_hd__fill_1
XFILLER_40_77 VGND VGND VPWR VPWR sky130_fd_sc_hd__fill_4
XFILLER_6_3 VPWR VGND VPWR VGND sky130_ef_sc_hd__decap_40_12
XFILLER_2_401 VGND VGND VPWR VPWR sky130_fd_sc_hd__fill_4
XFILLER_45_165 VGND VGND VPWR VPWR sky130_fd_sc_hd__fill_2
XFILLER_1_27 VPWR VGND VPWR VGND sky130_ef_sc_hd__decap_40_12
X_357_ _357_/A _376_/B VGND VGND VPWR VPWR _357_/X sky130_fd_sc_hd__or2_1
XFILLER_41_393 VGND VGND VPWR VPWR sky130_fd_sc_hd__fill_1
X_426_ _427_/B _427_/C _427_/A VGND VGND VPWR VPWR _428_/B sky130_fd_sc_hd__a21o_1
X_288_ _289_/C VGND VGND VPWR VPWR _288_/Y sky130_fd_sc_hd__inv_2
XFILLER_5_261 VPWR VGND VPWR VGND sky130_ef_sc_hd__decap_40_12
XFILLER_39_3 VPWR VGND VPWR VGND sky130_ef_sc_hd__decap_40_12
XFILLER_51_113 VPWR VGND VPWR VGND sky130_ef_sc_hd__decap_40_12
XFILLER_36_165 VGND VGND VPWR VPWR sky130_fd_sc_hd__fill_2
XFILLER_36_121 VPWR VGND VPWR VGND sky130_ef_sc_hd__decap_40_12
XFILLER_24_327 VGND VGND VPWR VPWR sky130_fd_sc_hd__fill_1
XFILLER_24_338 VGND VGND VPWR VPWR sky130_fd_sc_hd__fill_1
XTAP_TAPCELL_ROW_34_377 VGND VPWR sky130_fd_sc_hd__tapvpwrvgnd_1
XFILLER_59_279 VGND VGND VPWR VPWR sky130_fd_sc_hd__fill_1
XFILLER_27_165 VGND VGND VPWR VPWR sky130_fd_sc_hd__fill_2
XFILLER_15_305 VPWR VGND VPWR VGND sky130_ef_sc_hd__decap_40_12
XFILLER_35_55 VGND VGND VPWR VPWR sky130_fd_sc_hd__fill_1
XFILLER_15_349 VPWR VGND VPWR VGND sky130_ef_sc_hd__decap_40_12
XFILLER_2_253 VPWR VGND VPWR VGND sky130_ef_sc_hd__decap_40_12
XFILLER_33_113 VPWR VGND VPWR VGND sky130_ef_sc_hd__decap_40_12
XFILLER_18_121 VPWR VGND VPWR VGND sky130_ef_sc_hd__decap_40_12
XFILLER_18_165 VPWR VGND VPWR VGND sky130_ef_sc_hd__decap_40_12
X_409_ _412_/B _532_/Q _412_/D VGND VGND VPWR VPWR _411_/A sky130_fd_sc_hd__and3_1
XTAP_TAPCELL_ROW_31_358 VGND VPWR sky130_fd_sc_hd__tapvpwrvgnd_1
XFILLER_56_249 VGND VGND VPWR VPWR sky130_fd_sc_hd__fill_2
XTAP_TAPCELL_ROW_39_414 VGND VPWR sky130_fd_sc_hd__tapvpwrvgnd_1
XFILLER_2_81 VGND VGND VPWR VPWR sky130_fd_sc_hd__fill_2
XFILLER_64_293 VPWR VGND VPWR VGND sky130_ef_sc_hd__decap_40_12
XFILLER_20_341 VGND VGND VPWR VPWR sky130_fd_sc_hd__fill_2
XFILLER_21_57 VPWR VGND VPWR VGND sky130_ef_sc_hd__decap_40_12
XFILLER_47_205 VPWR VGND VPWR VGND sky130_ef_sc_hd__decap_40_12
XFILLER_55_293 VPWR VGND VPWR VGND sky130_ef_sc_hd__decap_40_12
XFILLER_47_249 VPWR VGND VPWR VGND sky130_ef_sc_hd__decap_40_12
XFILLER_46_65 VPWR VGND VPWR VGND sky130_ef_sc_hd__decap_40_12
XFILLER_15_113 VPWR VGND VPWR VGND sky130_ef_sc_hd__decap_40_12
XFILLER_62_97 VPWR VGND VPWR VGND sky130_ef_sc_hd__decap_40_12
XFILLER_62_53 VPWR VGND VPWR VGND sky130_ef_sc_hd__decap_40_12
XFILLER_7_15 VPWR VGND VPWR VGND sky130_ef_sc_hd__decap_40_12
XFILLER_11_385 VGND VGND VPWR VPWR sky130_fd_sc_hd__fill_4
XFILLER_7_389 VGND VGND VPWR VPWR sky130_fd_sc_hd__fill_2
XTAP_TAPCELL_ROW_44_450 VGND VPWR sky130_fd_sc_hd__tapvpwrvgnd_1
XFILLER_21_105 VGND VGND VPWR VPWR sky130_fd_sc_hd__fill_4
XFILLER_21_149 VPWR VGND VPWR VGND sky130_ef_sc_hd__decap_40_12
XFILLER_8_109 VPWR VGND VPWR VGND sky130_ef_sc_hd__decap_40_12
XFILLER_20_193 VGND VGND VPWR VPWR sky130_fd_sc_hd__fill_2
XTAP_TAPCELL_ROW_7_186 VGND VPWR sky130_fd_sc_hd__tapvpwrvgnd_1
XFILLER_43_296 VPWR VGND VPWR VGND sky130_ef_sc_hd__decap_40_12
XFILLER_43_263 VPWR VGND VPWR VGND sky130_ef_sc_hd__decap_40_12
Xhold109 _522_/Q VGND VGND VPWR VPWR _379_/A sky130_fd_sc_hd__dlygate4sd3_1
XFILLER_11_193 VPWR VGND VPWR VGND sky130_ef_sc_hd__decap_40_12
XFILLER_21_3 VPWR VGND VPWR VGND sky130_ef_sc_hd__decap_40_12
XFILLER_26_208 VPWR VGND VPWR VGND sky130_ef_sc_hd__decap_40_12
XTAP_TAPCELL_ROW_64_589 VGND VPWR sky130_fd_sc_hd__tapvpwrvgnd_1
XFILLER_1_329 VGND VGND VPWR VPWR sky130_fd_sc_hd__fill_4
XFILLER_57_333 VGND VGND VPWR VPWR sky130_fd_sc_hd__fill_2
XTAP_TAPCELL_ROW_4_167 VGND VPWR sky130_fd_sc_hd__tapvpwrvgnd_1
XTAP_TAPCELL_ROW_55_523 VGND VPWR sky130_fd_sc_hd__tapvpwrvgnd_1
XFILLER_43_55 VGND VGND VPWR VPWR sky130_fd_sc_hd__fill_1
X_390_ _390_/A _390_/B _390_/C _390_/D VGND VGND VPWR VPWR _391_/B sky130_fd_sc_hd__or4_1
XFILLER_25_241 VGND VGND VPWR VPWR sky130_fd_sc_hd__fill_2
XFILLER_4_189 VGND VGND VPWR VPWR sky130_fd_sc_hd__fill_4
XFILLER_4_27 VGND VGND VPWR VPWR sky130_fd_sc_hd__fill_1
XFILLER_48_377 VPWR VGND VPWR VGND sky130_ef_sc_hd__decap_40_12
XFILLER_48_333 VPWR VGND VPWR VGND sky130_ef_sc_hd__decap_40_12
XFILLER_31_233 VPWR VGND VPWR VGND sky130_ef_sc_hd__decap_40_12
XFILLER_31_200 VGND VGND VPWR VPWR sky130_fd_sc_hd__fill_1
XTAP_TAPCELL_ROW_18_269 VGND VPWR sky130_fd_sc_hd__tapvpwrvgnd_1
XFILLER_39_355 VGND VGND VPWR VPWR sky130_fd_sc_hd__fill_4
XTAP_TAPCELL_ROW_52_504 VGND VPWR sky130_fd_sc_hd__tapvpwrvgnd_1
XTAP_TAPCELL_ROW_1_148 VGND VPWR sky130_fd_sc_hd__tapvpwrvgnd_1
XFILLER_22_233 VGND VGND VPWR VPWR sky130_fd_sc_hd__fill_4
XFILLER_13_69 VPWR VGND VPWR VGND sky130_ef_sc_hd__decap_40_12
XFILLER_1_137 VPWR VGND VPWR VGND sky130_ef_sc_hd__decap_40_12
XTAP_TAPCELL_ROW_9_204 VGND VPWR sky130_fd_sc_hd__tapvpwrvgnd_1
XFILLER_38_77 VGND VGND VPWR VPWR sky130_fd_sc_hd__fill_4
X_511_ _523_/CLK _511_/D VGND VGND VPWR VPWR _511_/Q sky130_fd_sc_hd__dfxtp_1
XFILLER_54_65 VPWR VGND VPWR VGND sky130_ef_sc_hd__decap_40_12
XFILLER_53_391 VGND VGND VPWR VPWR sky130_fd_sc_hd__fill_1
X_373_ _387_/A _356_/Y _374_/C _372_/X VGND VGND VPWR VPWR _373_/X sky130_fd_sc_hd__o211a_1
XFILLER_9_237 VPWR VGND VPWR VGND sky130_ef_sc_hd__decap_40_12
XFILLER_13_277 VGND VGND VPWR VPWR sky130_fd_sc_hd__fill_2
X_442_ _442_/A _442_/B _442_/C VGND VGND VPWR VPWR _444_/B sky130_fd_sc_hd__and3_1
XFILLER_48_141 VPWR VGND VPWR VGND sky130_ef_sc_hd__decap_40_12
XFILLER_0_181 VGND VGND VPWR VPWR sky130_fd_sc_hd__fill_8
XFILLER_63_111 VGND VGND VPWR VPWR sky130_fd_sc_hd__fill_1
XFILLER_51_317 VPWR VGND VPWR VGND sky130_ef_sc_hd__decap_40_12
XFILLER_5_81 VPWR VGND VPWR VGND sky130_ef_sc_hd__decap_40_12
XFILLER_54_133 VGND VGND VPWR VPWR sky130_fd_sc_hd__fill_4
XFILLER_54_177 VPWR VGND VPWR VGND sky130_ef_sc_hd__decap_40_12
XFILLER_50_361 VGND VGND VPWR VPWR sky130_fd_sc_hd__fill_2
XTAP_TAPCELL_ROW_37_397 VGND VPWR sky130_fd_sc_hd__tapvpwrvgnd_1
XFILLER_35_391 VGND VGND VPWR VPWR sky130_fd_sc_hd__fill_1
XFILLER_45_111 VGND VGND VPWR VPWR sky130_fd_sc_hd__fill_1
XFILLER_1_39 VPWR VGND VPWR VGND sky130_ef_sc_hd__decap_40_12
X_287_ _523_/Q _379_/A _521_/Q _385_/A VGND VGND VPWR VPWR _287_/X sky130_fd_sc_hd__or4b_1
X_356_ _390_/C _379_/D VGND VGND VPWR VPWR _356_/Y sky130_fd_sc_hd__nand2_2
X_425_ _427_/B _427_/C _424_/Y VGND VGND VPWR VPWR _425_/Y sky130_fd_sc_hd__a21oi_1
XTAP_TAPCELL_ROW_11_220 VGND VPWR sky130_fd_sc_hd__tapvpwrvgnd_1
XFILLER_5_273 VGND VGND VPWR VPWR sky130_fd_sc_hd__fill_4
XFILLER_36_133 VGND VGND VPWR VPWR sky130_fd_sc_hd__fill_4
XFILLER_51_169 VPWR VGND VPWR VGND sky130_ef_sc_hd__decap_40_12
XFILLER_51_125 VPWR VGND VPWR VGND sky130_ef_sc_hd__decap_40_12
XTAP_TAPCELL_ROW_34_378 VGND VPWR sky130_fd_sc_hd__tapvpwrvgnd_1
XFILLER_17_391 VGND VGND VPWR VPWR sky130_fd_sc_hd__fill_1
XFILLER_10_15 VPWR VGND VPWR VGND sky130_ef_sc_hd__decap_40_12
XFILLER_59_225 VPWR VGND VPWR VGND sky130_ef_sc_hd__decap_40_12
XFILLER_27_111 VGND VGND VPWR VPWR sky130_fd_sc_hd__fill_1
XTAP_TAPCELL_ROW_25_312 VGND VPWR sky130_fd_sc_hd__tapvpwrvgnd_1
XFILLER_15_317 VPWR VGND VPWR VGND sky130_ef_sc_hd__decap_40_12
XFILLER_19_57 VPWR VGND VPWR VGND sky130_ef_sc_hd__decap_40_12
XFILLER_51_55 VGND VGND VPWR VPWR sky130_fd_sc_hd__fill_1
XFILLER_23_372 VGND VGND VPWR VPWR sky130_fd_sc_hd__fill_1
XFILLER_2_265 VPWR VGND VPWR VGND sky130_ef_sc_hd__decap_40_12
XFILLER_2_221 VPWR VGND VPWR VGND sky130_ef_sc_hd__decap_40_12
XFILLER_18_133 VGND VGND VPWR VPWR sky130_fd_sc_hd__fill_4
XFILLER_33_125 VPWR VGND VPWR VGND sky130_ef_sc_hd__decap_40_12
X_408_ _408_/A _408_/B VGND VGND VPWR VPWR _532_/D sky130_fd_sc_hd__nor2_1
XFILLER_14_361 VGND VGND VPWR VPWR sky130_fd_sc_hd__fill_2
XFILLER_18_177 VPWR VGND VPWR VGND sky130_ef_sc_hd__decap_40_12
X_339_ _544_/Q _505_/Q VGND VGND VPWR VPWR _339_/X sky130_fd_sc_hd__or2_1
XTAP_TAPCELL_ROW_31_359 VGND VPWR sky130_fd_sc_hd__tapvpwrvgnd_1
XFILLER_51_3 VPWR VGND VPWR VGND sky130_ef_sc_hd__decap_40_12
XFILLER_52_401 VGND VGND VPWR VPWR sky130_fd_sc_hd__fill_4
XTAP_TAPCELL_ROW_47_470 VGND VPWR sky130_fd_sc_hd__tapvpwrvgnd_1
XTAP_TAPCELL_ROW_39_415 VGND VPWR sky130_fd_sc_hd__tapvpwrvgnd_1
XFILLER_12_309 VPWR VGND VPWR VGND sky130_ef_sc_hd__decap_40_12
XFILLER_21_69 VPWR VGND VPWR VGND sky130_ef_sc_hd__decap_40_12
XFILLER_47_217 VGND VGND VPWR VPWR sky130_fd_sc_hd__fill_4
XFILLER_62_209 VPWR VGND VPWR VGND sky130_ef_sc_hd__decap_40_12
XFILLER_55_261 VPWR VGND VPWR VGND sky130_ef_sc_hd__decap_40_12
XFILLER_46_77 VGND VGND VPWR VPWR sky130_fd_sc_hd__fill_4
XFILLER_15_125 VPWR VGND VPWR VGND sky130_ef_sc_hd__decap_40_12
XFILLER_15_169 VPWR VGND VPWR VGND sky130_ef_sc_hd__decap_40_12
XFILLER_62_65 VPWR VGND VPWR VGND sky130_ef_sc_hd__decap_40_12
XFILLER_30_139 VGND VGND VPWR VPWR sky130_fd_sc_hd__fill_1
XFILLER_7_27 VPWR VGND VPWR VGND sky130_ef_sc_hd__decap_40_12
XFILLER_7_335 VGND VGND VPWR VPWR sky130_fd_sc_hd__fill_1
XTAP_TAPCELL_ROW_44_451 VGND VPWR sky130_fd_sc_hd__tapvpwrvgnd_1
XFILLER_52_253 VPWR VGND VPWR VGND sky130_ef_sc_hd__decap_40_12
XFILLER_44_209 VGND VGND VPWR VPWR sky130_fd_sc_hd__fill_2
XFILLER_37_283 VGND VGND VPWR VPWR sky130_fd_sc_hd__fill_1
XTAP_TAPCELL_ROW_50_487 VGND VPWR sky130_fd_sc_hd__tapvpwrvgnd_1
XFILLER_4_305 VGND VGND VPWR VPWR sky130_fd_sc_hd__fill_2
XFILLER_12_139 VGND VGND VPWR VPWR sky130_fd_sc_hd__fill_1
XTAP_TAPCELL_ROW_58_543 VGND VPWR sky130_fd_sc_hd__tapvpwrvgnd_1
XFILLER_28_272 VGND VGND VPWR VPWR sky130_fd_sc_hd__fill_1
XFILLER_28_261 VGND VGND VPWR VPWR sky130_fd_sc_hd__fill_1
XTAP_TAPCELL_ROW_7_187 VGND VPWR sky130_fd_sc_hd__tapvpwrvgnd_1
XFILLER_16_401 VGND VGND VPWR VPWR sky130_fd_sc_hd__fill_4
XFILLER_43_275 VGND VGND VPWR VPWR sky130_fd_sc_hd__fill_1
XFILLER_7_165 VGND VGND VPWR VPWR sky130_fd_sc_hd__fill_2
XFILLER_11_161 VGND VGND VPWR VPWR sky130_fd_sc_hd__fill_4
XFILLER_3_393 VPWR VGND VPWR VGND sky130_ef_sc_hd__decap_40_12
XFILLER_14_3 VPWR VGND VPWR VGND sky130_ef_sc_hd__decap_40_12
XFILLER_34_275 VGND VGND VPWR VPWR sky130_fd_sc_hd__fill_1
XPHY_EDGE_ROW_14_Left_79 VGND VGND VPWR VPWR sky130_fd_sc_hd__decap_3
XFILLER_8_81 VGND VGND VPWR VPWR sky130_fd_sc_hd__fill_2
XFILLER_57_389 VGND VGND VPWR VPWR sky130_fd_sc_hd__fill_2
XTAP_TAPCELL_ROW_55_524 VGND VPWR sky130_fd_sc_hd__tapvpwrvgnd_1
XFILLER_27_57 VPWR VGND VPWR VGND sky130_ef_sc_hd__decap_40_12
XTAP_TAPCELL_ROW_4_168 VGND VPWR sky130_fd_sc_hd__tapvpwrvgnd_1
XFILLER_40_267 VGND VGND VPWR VPWR sky130_fd_sc_hd__fill_1
XFILLER_40_223 VGND VGND VPWR VPWR sky130_fd_sc_hd__fill_2
XFILLER_25_297 VGND VGND VPWR VPWR sky130_fd_sc_hd__fill_1
XFILLER_48_301 VGND VGND VPWR VPWR sky130_fd_sc_hd__fill_4
XFILLER_0_363 VGND VGND VPWR VPWR sky130_fd_sc_hd__fill_1
XFILLER_63_337 VPWR VGND VPWR VGND sky130_ef_sc_hd__decap_40_12
XFILLER_48_389 VPWR VGND VPWR VGND sky130_ef_sc_hd__decap_40_12
XFILLER_48_345 VPWR VGND VPWR VGND sky130_ef_sc_hd__decap_40_12
XFILLER_16_253 VPWR VGND VPWR VGND sky130_ef_sc_hd__decap_40_12
XFILLER_31_245 VPWR VGND VPWR VGND sky130_ef_sc_hd__decap_40_12
XFILLER_31_223 VGND VGND VPWR VPWR sky130_fd_sc_hd__fill_1
XFILLER_58_109 VPWR VGND VPWR VGND sky130_ef_sc_hd__decap_40_12
XFILLER_39_345 VGND VGND VPWR VPWR sky130_fd_sc_hd__fill_4
XFILLER_39_334 VGND VGND VPWR VPWR sky130_fd_sc_hd__fill_2
XANTENNA_clkbuf_3_3__f_clk_A clkbuf_0_clk/X VGND VGND VPWR VPWR sky130_fd_sc_hd__diode_2
XTAP_TAPCELL_ROW_1_149 VGND VPWR sky130_fd_sc_hd__tapvpwrvgnd_1
XTAP_TAPCELL_ROW_52_505 VGND VPWR sky130_fd_sc_hd__tapvpwrvgnd_1
XFILLER_13_15 VPWR VGND VPWR VGND sky130_ef_sc_hd__decap_40_12
XFILLER_22_267 VPWR VGND VPWR VGND sky130_ef_sc_hd__decap_40_12
XTAP_TAPCELL_ROW_60_560 VGND VPWR sky130_fd_sc_hd__tapvpwrvgnd_1
XTAP_TAPCELL_ROW_9_205 VGND VPWR sky130_fd_sc_hd__tapvpwrvgnd_1
XFILLER_49_109 VGND VGND VPWR VPWR sky130_fd_sc_hd__fill_2
XFILLER_1_105 VGND VGND VPWR VPWR sky130_fd_sc_hd__fill_4
XFILLER_1_149 VPWR VGND VPWR VGND sky130_ef_sc_hd__decap_40_12
XFILLER_60_307 VGND VGND VPWR VPWR sky130_fd_sc_hd__fill_1
XFILLER_45_337 VPWR VGND VPWR VGND sky130_ef_sc_hd__decap_40_12
XFILLER_45_304 VPWR VGND VPWR VGND sky130_ef_sc_hd__decap_40_12
X_510_ _523_/CLK _510_/D VGND VGND VPWR VPWR _510_/Q sky130_fd_sc_hd__dfxtp_1
X_441_ _442_/A _441_/B VGND VGND VPWR VPWR _443_/C sky130_fd_sc_hd__or2_1
XFILLER_54_77 VGND VGND VPWR VPWR sky130_fd_sc_hd__fill_4
X_372_ _520_/Q _376_/B VGND VGND VPWR VPWR _372_/X sky130_fd_sc_hd__or2_1
XFILLER_9_205 VPWR VGND VPWR VGND sky130_ef_sc_hd__decap_40_12
XFILLER_9_249 VPWR VGND VPWR VGND sky130_ef_sc_hd__decap_40_12
XFILLER_13_223 VGND VGND VPWR VPWR sky130_fd_sc_hd__fill_1
XFILLER_48_153 VPWR VGND VPWR VGND sky130_ef_sc_hd__decap_40_12
XFILLER_63_167 VGND VGND VPWR VPWR sky130_fd_sc_hd__fill_1
XFILLER_51_329 VGND VGND VPWR VPWR sky130_fd_sc_hd__fill_4
XFILLER_48_197 VPWR VGND VPWR VGND sky130_ef_sc_hd__decap_40_12
XTAP_TAPCELL_ROW_14_240 VGND VPWR sky130_fd_sc_hd__tapvpwrvgnd_1
XANTENNA__303__A2 _283_/X VGND VGND VPWR VPWR sky130_fd_sc_hd__diode_2
XFILLER_5_93 VPWR VGND VPWR VGND sky130_ef_sc_hd__decap_40_12
XFILLER_42_307 VGND VGND VPWR VPWR sky130_fd_sc_hd__fill_1
XFILLER_27_337 VGND VGND VPWR VPWR sky130_fd_sc_hd__fill_2
XFILLER_54_189 VGND VGND VPWR VPWR sky130_fd_sc_hd__fill_4
XFILLER_42_329 VGND VGND VPWR VPWR sky130_fd_sc_hd__fill_1
XTAP_TAPCELL_ROW_37_398 VGND VPWR sky130_fd_sc_hd__tapvpwrvgnd_1
XFILLER_35_370 VGND VGND VPWR VPWR sky130_fd_sc_hd__fill_1
XPHY_EDGE_ROW_17_Left_82 VGND VGND VPWR VPWR sky130_fd_sc_hd__decap_3
XFILLER_49_55 VGND VGND VPWR VPWR sky130_fd_sc_hd__fill_1
XFILLER_60_137 VGND VGND VPWR VPWR sky130_fd_sc_hd__fill_2
XFILLER_45_167 VGND VGND VPWR VPWR sky130_fd_sc_hd__fill_1
X_424_ _427_/B _427_/C _428_/A VGND VGND VPWR VPWR _424_/Y sky130_fd_sc_hd__o21ai_1
XFILLER_41_373 VGND VGND VPWR VPWR sky130_fd_sc_hd__fill_1
X_355_ _390_/C _379_/D VGND VGND VPWR VPWR _376_/B sky130_fd_sc_hd__and2_2
X_286_ _486_/Q _283_/X _285_/Y _434_/B _485_/A VGND VGND VPWR VPWR _286_/X sky130_fd_sc_hd__a221o_1
XFILLER_24_307 VGND VGND VPWR VPWR sky130_fd_sc_hd__fill_1
XFILLER_51_137 VPWR VGND VPWR VGND sky130_ef_sc_hd__decap_40_12
XTAP_TAPCELL_ROW_34_379 VGND VPWR sky130_fd_sc_hd__tapvpwrvgnd_1
XFILLER_10_27 VGND VGND VPWR VPWR sky130_fd_sc_hd__fill_1
XFILLER_59_237 VPWR VGND VPWR VGND sky130_ef_sc_hd__decap_40_12
XFILLER_19_69 VPWR VGND VPWR VGND sky130_ef_sc_hd__decap_40_12
XFILLER_42_137 VGND VGND VPWR VPWR sky130_fd_sc_hd__fill_2
XFILLER_35_57 VPWR VGND VPWR VGND sky130_ef_sc_hd__decap_40_12
XFILLER_27_167 VGND VGND VPWR VPWR sky130_fd_sc_hd__fill_1
XTAP_TAPCELL_ROW_25_313 VGND VPWR sky130_fd_sc_hd__tapvpwrvgnd_1
XFILLER_15_329 VGND VGND VPWR VPWR sky130_fd_sc_hd__fill_4
Xclkbuf_3_3__f_clk clkbuf_0_clk/X VGND VGND VPWR VPWR _544_/CLK sky130_fd_sc_hd__clkbuf_16
XPHY_EDGE_ROW_2_Left_67 VGND VGND VPWR VPWR sky130_fd_sc_hd__decap_3
XPHY_EDGE_ROW_14_Right_14 VGND VGND VPWR VPWR sky130_fd_sc_hd__decap_3
XFILLER_2_277 VPWR VGND VPWR VGND sky130_ef_sc_hd__decap_40_12
XFILLER_2_233 VPWR VGND VPWR VGND sky130_ef_sc_hd__decap_40_12
XPHY_EDGE_ROW_23_Right_23 VGND VGND VPWR VPWR sky130_fd_sc_hd__decap_3
XFILLER_33_137 VPWR VGND VPWR VGND sky130_ef_sc_hd__decap_40_12
XPHY_EDGE_ROW_32_Right_32 VGND VGND VPWR VPWR sky130_fd_sc_hd__decap_3
X_407_ _406_/A _412_/D _428_/A VGND VGND VPWR VPWR _407_/Y sky130_fd_sc_hd__o21ai_1
X_338_ _434_/A _436_/B _337_/X _336_/X VGND VGND VPWR VPWR _338_/X sky130_fd_sc_hd__a31o_1
XFILLER_18_189 VGND VGND VPWR VPWR sky130_fd_sc_hd__fill_4
X_269_ _390_/B _387_/B _268_/X VGND VGND VPWR VPWR _379_/D sky130_fd_sc_hd__a21bo_2
XFILLER_44_3 VPWR VGND VPWR VGND sky130_ef_sc_hd__decap_40_12
XPHY_EDGE_ROW_41_Right_41 VGND VGND VPWR VPWR sky130_fd_sc_hd__decap_3
XTAP_TAPCELL_ROW_39_416 VGND VPWR sky130_fd_sc_hd__tapvpwrvgnd_1
XFILLER_64_251 VGND VGND VPWR VPWR sky130_fd_sc_hd__fill_1
XPHY_EDGE_ROW_50_Right_50 VGND VGND VPWR VPWR sky130_fd_sc_hd__decap_3
XFILLER_49_281 VPWR VGND VPWR VGND sky130_ef_sc_hd__decap_40_12
XTAP_TAPCELL_ROW_47_471 VGND VPWR sky130_fd_sc_hd__tapvpwrvgnd_1
XFILLER_2_83 VGND VGND VPWR VPWR sky130_fd_sc_hd__fill_1
XFILLER_24_137 VGND VGND VPWR VPWR sky130_fd_sc_hd__fill_2
XFILLER_21_15 VPWR VGND VPWR VGND sky130_ef_sc_hd__decap_40_12
XFILLER_62_77 VGND VGND VPWR VPWR sky130_fd_sc_hd__fill_4
XFILLER_55_273 VGND VGND VPWR VPWR sky130_fd_sc_hd__fill_4
XFILLER_15_137 VPWR VGND VPWR VGND sky130_ef_sc_hd__decap_40_12
XFILLER_23_181 VPWR VGND VPWR VGND sky130_ef_sc_hd__decap_40_12
XFILLER_7_39 VPWR VGND VPWR VGND sky130_ef_sc_hd__decap_40_12
XFILLER_11_81 VPWR VGND VPWR VGND sky130_ef_sc_hd__decap_40_12
XFILLER_61_221 VGND VGND VPWR VPWR sky130_fd_sc_hd__fill_2
XFILLER_46_251 VGND VGND VPWR VPWR sky130_fd_sc_hd__fill_1
XFILLER_52_265 VPWR VGND VPWR VGND sky130_ef_sc_hd__decap_40_12
XFILLER_52_221 VPWR VGND VPWR VGND sky130_ef_sc_hd__decap_40_12
XFILLER_37_273 VGND VGND VPWR VPWR sky130_fd_sc_hd__fill_4
XFILLER_16_15 VPWR VGND VPWR VGND sky130_ef_sc_hd__decap_40_12
XTAP_TAPCELL_ROW_50_488 VGND VPWR sky130_fd_sc_hd__tapvpwrvgnd_1
XFILLER_20_195 VGND VGND VPWR VPWR sky130_fd_sc_hd__fill_1
XTAP_TAPCELL_ROW_7_188 VGND VPWR sky130_fd_sc_hd__tapvpwrvgnd_1
XTAP_TAPCELL_ROW_58_544 VGND VPWR sky130_fd_sc_hd__tapvpwrvgnd_1
XFILLER_57_55 VGND VGND VPWR VPWR sky130_fd_sc_hd__fill_1
XFILLER_7_111 VGND VGND VPWR VPWR sky130_fd_sc_hd__fill_1
XPHY_EDGE_ROW_5_Left_70 VGND VGND VPWR VPWR sky130_fd_sc_hd__decap_3
XFILLER_3_361 VPWR VGND VPWR VGND sky130_ef_sc_hd__decap_40_12
XFILLER_34_298 VGND VGND VPWR VPWR sky130_fd_sc_hd__fill_2
XPHY_EDGE_ROW_4_Right_4 VGND VGND VPWR VPWR sky130_fd_sc_hd__decap_3
XFILLER_57_335 VGND VGND VPWR VPWR sky130_fd_sc_hd__fill_1
XTAP_TAPCELL_ROW_55_525 VGND VPWR sky130_fd_sc_hd__tapvpwrvgnd_1
XFILLER_27_69 VPWR VGND VPWR VGND sky130_ef_sc_hd__decap_40_12
XTAP_TAPCELL_ROW_4_169 VGND VPWR sky130_fd_sc_hd__tapvpwrvgnd_1
XTAP_TAPCELL_ROW_63_580 VGND VPWR sky130_fd_sc_hd__tapvpwrvgnd_1
XFILLER_43_57 VPWR VGND VPWR VGND sky130_ef_sc_hd__decap_40_12
XFILLER_13_405 VGND VGND VPWR VPWR sky130_fd_sc_hd__fill_2
XFILLER_4_29 VPWR VGND VPWR VGND sky130_ef_sc_hd__decap_40_12
XFILLER_48_357 VGND VGND VPWR VPWR sky130_fd_sc_hd__fill_4
XPHY_EDGE_ROW_31_Left_96 VGND VGND VPWR VPWR sky130_fd_sc_hd__decap_3
XFILLER_63_349 VPWR VGND VPWR VGND sky130_ef_sc_hd__decap_40_12
XFILLER_63_305 VPWR VGND VPWR VGND sky130_ef_sc_hd__decap_40_12
XFILLER_16_221 VPWR VGND VPWR VGND sky130_ef_sc_hd__decap_40_12
XFILLER_16_265 VPWR VGND VPWR VGND sky130_ef_sc_hd__decap_40_12
XFILLER_31_279 VGND VGND VPWR VPWR sky130_fd_sc_hd__fill_1
XFILLER_31_257 VGND VGND VPWR VPWR sky130_fd_sc_hd__fill_4
XFILLER_54_305 VGND VGND VPWR VPWR sky130_fd_sc_hd__fill_2
XTAP_TAPCELL_ROW_60_561 VGND VPWR sky130_fd_sc_hd__tapvpwrvgnd_1
XTAP_TAPCELL_ROW_52_506 VGND VPWR sky130_fd_sc_hd__tapvpwrvgnd_1
XFILLER_13_27 VPWR VGND VPWR VGND sky130_ef_sc_hd__decap_40_12
XTAP_TAPCELL_ROW_17_260 VGND VPWR sky130_fd_sc_hd__tapvpwrvgnd_1
XTAP_TAPCELL_ROW_9_206 VGND VPWR sky130_fd_sc_hd__tapvpwrvgnd_1
XFILLER_57_165 VGND VGND VPWR VPWR sky130_fd_sc_hd__fill_2
XFILLER_53_393 VPWR VGND VPWR VGND sky130_ef_sc_hd__decap_40_12
XFILLER_45_349 VPWR VGND VPWR VGND sky130_ef_sc_hd__decap_40_12
XFILLER_45_316 VPWR VGND VPWR VGND sky130_ef_sc_hd__decap_40_12
X_371_ hold26/X _356_/Y _374_/C _370_/X VGND VGND VPWR VPWR _371_/X sky130_fd_sc_hd__o211a_1
X_440_ _441_/B _445_/A _440_/C VGND VGND VPWR VPWR _548_/D sky130_fd_sc_hd__and3b_1
XFILLER_9_217 VGND VGND VPWR VPWR sky130_fd_sc_hd__fill_4
XFILLER_13_279 VGND VGND VPWR VPWR sky130_fd_sc_hd__fill_1
XFILLER_63_113 VPWR VGND VPWR VGND sky130_ef_sc_hd__decap_40_12
XFILLER_48_165 VPWR VGND VPWR VGND sky130_ef_sc_hd__decap_40_12
XFILLER_48_121 VPWR VGND VPWR VGND sky130_ef_sc_hd__decap_40_12
XTAP_TAPCELL_ROW_14_241 VGND VPWR sky130_fd_sc_hd__tapvpwrvgnd_1
XFILLER_39_165 VGND VGND VPWR VPWR sky130_fd_sc_hd__fill_2
XTAP_TAPCELL_ROW_37_399 VGND VPWR sky130_fd_sc_hd__tapvpwrvgnd_1
XFILLER_24_15 VPWR VGND VPWR VGND sky130_ef_sc_hd__decap_40_12
XFILLER_50_363 VGND VGND VPWR VPWR sky130_fd_sc_hd__fill_1
XFILLER_6_209 VPWR VGND VPWR VGND sky130_ef_sc_hd__decap_40_12
XFILLER_10_249 VGND VGND VPWR VPWR sky130_fd_sc_hd__fill_2
XTAP_TAPCELL_ROW_20_277 VGND VPWR sky130_fd_sc_hd__tapvpwrvgnd_1
XFILLER_45_113 VPWR VGND VPWR VGND sky130_ef_sc_hd__decap_40_12
X_423_ _427_/C _423_/B VGND VGND VPWR VPWR _423_/Y sky130_fd_sc_hd__nor2_1
X_354_ hold26/X _374_/A _337_/B _353_/X VGND VGND VPWR VPWR _512_/D sky130_fd_sc_hd__o211a_1
XTAP_TAPCELL_ROW_28_333 VGND VPWR sky130_fd_sc_hd__tapvpwrvgnd_1
X_285_ _285_/A VGND VGND VPWR VPWR _285_/Y sky130_fd_sc_hd__inv_2
XFILLER_14_81 VGND VGND VPWR VPWR sky130_fd_sc_hd__fill_2
XFILLER_51_105 VGND VGND VPWR VPWR sky130_fd_sc_hd__fill_4
XFILLER_51_149 VPWR VGND VPWR VGND sky130_ef_sc_hd__decap_40_12
XFILLER_17_393 VPWR VGND VPWR VGND sky130_ef_sc_hd__decap_40_12
XFILLER_59_249 VPWR VGND VPWR VGND sky130_ef_sc_hd__decap_40_12
XFILLER_59_205 VPWR VGND VPWR VGND sky130_ef_sc_hd__decap_40_12
XFILLER_27_113 VPWR VGND VPWR VGND sky130_ef_sc_hd__decap_40_12
XFILLER_19_15 VPWR VGND VPWR VGND sky130_ef_sc_hd__decap_40_12
XFILLER_35_69 VPWR VGND VPWR VGND sky130_ef_sc_hd__decap_40_12
XTAP_TAPCELL_ROW_25_314 VGND VPWR sky130_fd_sc_hd__tapvpwrvgnd_1
XFILLER_51_57 VPWR VGND VPWR VGND sky130_ef_sc_hd__decap_40_12
XFILLER_50_193 VGND VGND VPWR VPWR sky130_fd_sc_hd__fill_2
XFILLER_4_3 VPWR VGND VPWR VGND sky130_ef_sc_hd__decap_40_12
XFILLER_2_289 VPWR VGND VPWR VGND sky130_ef_sc_hd__decap_40_12
XFILLER_2_245 VGND VGND VPWR VPWR sky130_fd_sc_hd__fill_4
XFILLER_33_105 VGND VGND VPWR VPWR sky130_fd_sc_hd__fill_4
XFILLER_33_149 VGND VGND VPWR VPWR sky130_fd_sc_hd__fill_2
X_406_ _406_/A _412_/D VGND VGND VPWR VPWR _408_/A sky130_fd_sc_hd__and2_1
X_337_ _546_/Q _337_/B _337_/C VGND VGND VPWR VPWR _337_/X sky130_fd_sc_hd__and3_1
XFILLER_14_363 VGND VGND VPWR VPWR sky130_fd_sc_hd__fill_1
X_268_ _268_/A _268_/B _268_/C _268_/D VGND VGND VPWR VPWR _268_/X sky130_fd_sc_hd__or4_1
XFILLER_49_293 VPWR VGND VPWR VGND sky130_ef_sc_hd__decap_40_12
XFILLER_37_3 VPWR VGND VPWR VGND sky130_ef_sc_hd__decap_40_12
XTAP_TAPCELL_ROW_47_472 VGND VPWR sky130_fd_sc_hd__tapvpwrvgnd_1
XFILLER_32_193 VGND VGND VPWR VPWR sky130_fd_sc_hd__fill_2
XTAP_TAPCELL_ROW_30_350 VGND VPWR sky130_fd_sc_hd__tapvpwrvgnd_1
XFILLER_20_333 VGND VGND VPWR VPWR sky130_fd_sc_hd__fill_8
XFILLER_21_27 VPWR VGND VPWR VGND sky130_ef_sc_hd__decap_40_12
XFILLER_15_105 VGND VGND VPWR VPWR sky130_fd_sc_hd__fill_4
XFILLER_11_333 VGND VGND VPWR VPWR sky130_fd_sc_hd__fill_2
XFILLER_15_149 VPWR VGND VPWR VGND sky130_ef_sc_hd__decap_40_12
XFILLER_23_193 VPWR VGND VPWR VGND sky130_ef_sc_hd__decap_40_12
XFILLER_7_337 VPWR VGND VPWR VGND sky130_ef_sc_hd__decap_40_12
XFILLER_11_93 VPWR VGND VPWR VGND sky130_ef_sc_hd__decap_40_12
XFILLER_61_277 VGND VGND VPWR VPWR sky130_fd_sc_hd__fill_2
XFILLER_14_193 VGND VGND VPWR VPWR sky130_fd_sc_hd__fill_2
XFILLER_52_277 VPWR VGND VPWR VGND sky130_ef_sc_hd__decap_40_12
XFILLER_52_233 VPWR VGND VPWR VGND sky130_ef_sc_hd__decap_40_12
XFILLER_32_15 VPWR VGND VPWR VGND sky130_ef_sc_hd__decap_40_12
XFILLER_16_27 VGND VGND VPWR VPWR sky130_fd_sc_hd__fill_1
XFILLER_20_141 VPWR VGND VPWR VGND sky130_ef_sc_hd__decap_40_12
XTAP_TAPCELL_ROW_50_489 VGND VPWR sky130_fd_sc_hd__tapvpwrvgnd_1
XFILLER_4_307 VGND VGND VPWR VPWR sky130_fd_sc_hd__fill_1
XTAP_TAPCELL_ROW_7_189 VGND VPWR sky130_fd_sc_hd__tapvpwrvgnd_1
XTAP_TAPCELL_ROW_58_545 VGND VPWR sky130_fd_sc_hd__tapvpwrvgnd_1
XFILLER_28_230 VGND VGND VPWR VPWR sky130_fd_sc_hd__fill_4
XPHY_EDGE_ROW_44_Left_109 VGND VGND VPWR VPWR sky130_fd_sc_hd__decap_3
XFILLER_43_288 VGND VGND VPWR VPWR sky130_fd_sc_hd__fill_2
XANTENNA__291__A _485_/A VGND VGND VPWR VPWR sky130_fd_sc_hd__diode_2
XFILLER_3_373 VPWR VGND VPWR VGND sky130_ef_sc_hd__decap_40_12
XFILLER_7_167 VGND VGND VPWR VPWR sky130_fd_sc_hd__fill_1
XFILLER_22_81 VGND VGND VPWR VPWR sky130_fd_sc_hd__fill_2
XPHY_EDGE_ROW_53_Left_118 VGND VGND VPWR VPWR sky130_fd_sc_hd__decap_3
XFILLER_19_241 VGND VGND VPWR VPWR sky130_fd_sc_hd__fill_2
XFILLER_19_263 VGND VGND VPWR VPWR sky130_fd_sc_hd__fill_1
XFILLER_34_244 VGND VGND VPWR VPWR sky130_fd_sc_hd__fill_4
XPHY_EDGE_ROW_62_Left_127 VGND VGND VPWR VPWR sky130_fd_sc_hd__decap_3
XFILLER_8_83 VGND VGND VPWR VPWR sky130_fd_sc_hd__fill_1
XTAP_TAPCELL_ROW_55_526 VGND VPWR sky130_fd_sc_hd__tapvpwrvgnd_1
XFILLER_27_15 VPWR VGND VPWR VGND sky130_ef_sc_hd__decap_40_12
XFILLER_25_266 VGND VGND VPWR VPWR sky130_fd_sc_hd__fill_8
XFILLER_25_255 VGND VGND VPWR VPWR sky130_fd_sc_hd__fill_2
XFILLER_25_222 VGND VGND VPWR VPWR sky130_fd_sc_hd__fill_2
XTAP_TAPCELL_ROW_63_581 VGND VPWR sky130_fd_sc_hd__tapvpwrvgnd_1
XFILLER_43_69 VPWR VGND VPWR VGND sky130_ef_sc_hd__decap_40_12
XFILLER_40_247 VGND VGND VPWR VPWR sky130_fd_sc_hd__fill_4
XFILLER_4_137 VGND VGND VPWR VPWR sky130_fd_sc_hd__fill_2
XFILLER_0_321 VPWR VGND VPWR VGND sky130_ef_sc_hd__decap_40_12
XFILLER_63_317 VPWR VGND VPWR VGND sky130_ef_sc_hd__decap_40_12
XFILLER_0_365 VPWR VGND VPWR VGND sky130_ef_sc_hd__decap_40_12
XFILLER_31_225 VGND VGND VPWR VPWR sky130_fd_sc_hd__fill_2
XFILLER_16_233 VPWR VGND VPWR VGND sky130_ef_sc_hd__decap_40_12
XFILLER_16_277 VPWR VGND VPWR VGND sky130_ef_sc_hd__decap_40_12
XFILLER_17_81 VPWR VGND VPWR VGND sky130_ef_sc_hd__decap_40_12
XFILLER_3_181 VPWR VGND VPWR VGND sky130_ef_sc_hd__decap_40_12
XTAP_TAPCELL_ROW_52_507 VGND VPWR sky130_fd_sc_hd__tapvpwrvgnd_1
XFILLER_47_391 VGND VGND VPWR VPWR sky130_fd_sc_hd__fill_1
XFILLER_62_361 VGND VGND VPWR VPWR sky130_fd_sc_hd__fill_2
XTAP_TAPCELL_ROW_60_562 VGND VPWR sky130_fd_sc_hd__tapvpwrvgnd_1
XFILLER_13_39 VPWR VGND VPWR VGND sky130_ef_sc_hd__decap_40_12
XTAP_TAPCELL_ROW_17_261 VGND VPWR sky130_fd_sc_hd__tapvpwrvgnd_1
XFILLER_57_111 VGND VGND VPWR VPWR sky130_fd_sc_hd__fill_1
XFILLER_60_309 VPWR VGND VPWR VGND sky130_ef_sc_hd__decap_40_12
XFILLER_53_361 VPWR VGND VPWR VGND sky130_ef_sc_hd__decap_40_12
XFILLER_45_328 VGND VGND VPWR VPWR sky130_fd_sc_hd__fill_8
X_370_ _519_/Q _376_/B VGND VGND VPWR VPWR _370_/X sky130_fd_sc_hd__or2_1
XTAP_TAPCELL_ROW_0_140 VGND VPWR sky130_fd_sc_hd__tapvpwrvgnd_1
XFILLER_13_225 VPWR VGND VPWR VGND sky130_ef_sc_hd__decap_40_12
XFILLER_63_169 VPWR VGND VPWR VGND sky130_ef_sc_hd__decap_40_12
XFILLER_63_125 VPWR VGND VPWR VGND sky130_ef_sc_hd__decap_40_12
XFILLER_48_177 VPWR VGND VPWR VGND sky130_ef_sc_hd__decap_40_12
XFILLER_48_133 VGND VGND VPWR VPWR sky130_fd_sc_hd__fill_4
XFILLER_29_391 VGND VGND VPWR VPWR sky130_fd_sc_hd__fill_1
XFILLER_44_361 VGND VGND VPWR VPWR sky130_fd_sc_hd__fill_2
X_499_ _565_/CLK _499_/D VGND VGND VPWR VPWR _499_/Q sky130_fd_sc_hd__dfxtp_1
XFILLER_5_51 VGND VGND VPWR VPWR sky130_fd_sc_hd__fill_4
XFILLER_8_251 VGND VGND VPWR VPWR sky130_fd_sc_hd__fill_1
XFILLER_39_111 VGND VGND VPWR VPWR sky130_fd_sc_hd__fill_1
XFILLER_42_309 VGND VGND VPWR VPWR sky130_fd_sc_hd__fill_4
XFILLER_24_27 VGND VGND VPWR VPWR sky130_fd_sc_hd__fill_1
XFILLER_40_15 VPWR VGND VPWR VGND sky130_ef_sc_hd__decap_40_12
XTAP_TAPCELL_ROW_20_278 VGND VPWR sky130_fd_sc_hd__tapvpwrvgnd_1
XFILLER_49_57 VPWR VGND VPWR VGND sky130_ef_sc_hd__decap_40_12
XFILLER_2_405 VGND VGND VPWR VPWR sky130_fd_sc_hd__fill_2
XFILLER_45_169 VPWR VGND VPWR VGND sky130_ef_sc_hd__decap_40_12
XFILLER_45_125 VPWR VGND VPWR VGND sky130_ef_sc_hd__decap_40_12
XTAP_TAPCELL_ROW_28_334 VGND VPWR sky130_fd_sc_hd__tapvpwrvgnd_1
XFILLER_60_139 VGND VGND VPWR VPWR sky130_fd_sc_hd__fill_1
X_422_ _421_/A _420_/A _428_/A VGND VGND VPWR VPWR _422_/Y sky130_fd_sc_hd__o21ai_1
X_353_ _353_/A _390_/B VGND VGND VPWR VPWR _353_/X sky130_fd_sc_hd__or2_1
X_284_ _444_/A _549_/Q _548_/Q _547_/Q VGND VGND VPWR VPWR _285_/A sky130_fd_sc_hd__or4b_1
XFILLER_30_81 VGND VGND VPWR VPWR sky130_fd_sc_hd__fill_2
XFILLER_5_221 VGND VGND VPWR VPWR sky130_fd_sc_hd__fill_2
XFILLER_17_361 VPWR VGND VPWR VGND sky130_ef_sc_hd__decap_40_12
XFILLER_24_309 VGND VGND VPWR VPWR sky130_fd_sc_hd__fill_1
XFILLER_59_217 VGND VGND VPWR VPWR sky130_fd_sc_hd__fill_4
XFILLER_10_29 VPWR VGND VPWR VGND sky130_ef_sc_hd__decap_40_12
XFILLER_35_15 VPWR VGND VPWR VGND sky130_ef_sc_hd__decap_40_12
XFILLER_27_125 VPWR VGND VPWR VGND sky130_ef_sc_hd__decap_40_12
XFILLER_19_27 VPWR VGND VPWR VGND sky130_ef_sc_hd__decap_40_12
XFILLER_42_139 VGND VGND VPWR VPWR sky130_fd_sc_hd__fill_1
XTAP_TAPCELL_ROW_33_370 VGND VPWR sky130_fd_sc_hd__tapvpwrvgnd_1
XFILLER_27_169 VPWR VGND VPWR VGND sky130_ef_sc_hd__decap_40_12
XTAP_TAPCELL_ROW_25_315 VGND VPWR sky130_fd_sc_hd__tapvpwrvgnd_1
XFILLER_23_364 VGND VGND VPWR VPWR sky130_fd_sc_hd__fill_1
XFILLER_51_69 VPWR VGND VPWR VGND sky130_ef_sc_hd__decap_40_12
XFILLER_46_401 VGND VGND VPWR VPWR sky130_fd_sc_hd__fill_4
XFILLER_41_161 VGND VGND VPWR VPWR sky130_fd_sc_hd__fill_4
X_267_ _535_/Q _534_/Q _533_/Q _532_/Q VGND VGND VPWR VPWR _268_/D sky130_fd_sc_hd__or4b_1
X_336_ _511_/Q _337_/C _335_/X _337_/B VGND VGND VPWR VPWR _336_/X sky130_fd_sc_hd__o211a_1
X_405_ _412_/D _405_/B VGND VGND VPWR VPWR _405_/Y sky130_fd_sc_hd__nor2_1
XFILLER_25_81 VPWR VGND VPWR VGND sky130_ef_sc_hd__decap_40_12
XFILLER_56_209 VPWR VGND VPWR VGND sky130_ef_sc_hd__decap_40_12
XFILLER_49_261 VPWR VGND VPWR VGND sky130_ef_sc_hd__decap_40_12
XFILLER_2_85 VPWR VGND VPWR VGND sky130_ef_sc_hd__decap_40_12
XFILLER_2_41 VPWR VGND VPWR VGND sky130_ef_sc_hd__decap_40_12
XFILLER_64_253 VPWR VGND VPWR VGND sky130_ef_sc_hd__decap_40_12
XFILLER_24_139 VGND VGND VPWR VPWR sky130_fd_sc_hd__fill_1
XTAP_TAPCELL_ROW_30_351 VGND VPWR sky130_fd_sc_hd__tapvpwrvgnd_1
XFILLER_21_39 VPWR VGND VPWR VGND sky130_ef_sc_hd__decap_40_12
XFILLER_30_109 VPWR VGND VPWR VGND sky130_ef_sc_hd__decap_40_12
XFILLER_7_305 VPWR VGND VPWR VGND sky130_ef_sc_hd__decap_40_12
XFILLER_11_389 VGND VGND VPWR VPWR sky130_fd_sc_hd__fill_2
XFILLER_23_161 VGND VGND VPWR VPWR sky130_fd_sc_hd__fill_4
XFILLER_7_349 VPWR VGND VPWR VGND sky130_ef_sc_hd__decap_40_12
XFILLER_61_223 VGND VGND VPWR VPWR sky130_fd_sc_hd__fill_1
XFILLER_46_253 VPWR VGND VPWR VGND sky130_ef_sc_hd__decap_40_12
XFILLER_21_109 VGND VGND VPWR VPWR sky130_fd_sc_hd__fill_2
X_319_ _319_/A1 _337_/C _318_/X _273_/A VGND VGND VPWR VPWR _319_/X sky130_fd_sc_hd__o211a_1
XFILLER_52_289 VPWR VGND VPWR VGND sky130_ef_sc_hd__decap_40_12
XFILLER_52_245 VGND VGND VPWR VPWR sky130_fd_sc_hd__fill_4
XFILLER_32_27 VGND VGND VPWR VPWR sky130_fd_sc_hd__fill_1
XFILLER_12_109 VPWR VGND VPWR VGND sky130_ef_sc_hd__decap_40_12
XFILLER_20_153 VPWR VGND VPWR VGND sky130_ef_sc_hd__decap_40_12
XANTENNA__336__C1 _337_/B VGND VGND VPWR VPWR sky130_fd_sc_hd__diode_2
XFILLER_20_197 VPWR VGND VPWR VGND sky130_ef_sc_hd__decap_40_12
XTAP_TAPCELL_ROW_58_546 VGND VPWR sky130_fd_sc_hd__tapvpwrvgnd_1
XFILLER_57_57 VPWR VGND VPWR VGND sky130_ef_sc_hd__decap_40_12
XFILLER_43_201 VGND VGND VPWR VPWR sky130_fd_sc_hd__fill_1
XFILLER_28_297 VGND VGND VPWR VPWR sky130_fd_sc_hd__fill_2
XTAP_TAPCELL_ROW_41_424 VGND VPWR sky130_fd_sc_hd__tapvpwrvgnd_1
XFILLER_7_113 VPWR VGND VPWR VGND sky130_ef_sc_hd__decap_40_12
XFILLER_3_385 VGND VGND VPWR VPWR sky130_fd_sc_hd__fill_4
XFILLER_34_201 VGND VGND VPWR VPWR sky130_fd_sc_hd__fill_1
XFILLER_57_337 VPWR VGND VPWR VGND sky130_ef_sc_hd__decap_40_12
XFILLER_27_27 VPWR VGND VPWR VGND sky130_ef_sc_hd__decap_40_12
XTAP_TAPCELL_ROW_63_582 VGND VPWR sky130_fd_sc_hd__tapvpwrvgnd_1
XTAP_TAPCELL_ROW_55_527 VGND VPWR sky130_fd_sc_hd__tapvpwrvgnd_1
XFILLER_43_15 VPWR VGND VPWR VGND sky130_ef_sc_hd__decap_40_12
XFILLER_40_259 VGND VGND VPWR VPWR sky130_fd_sc_hd__fill_4
XFILLER_0_333 VGND VGND VPWR VPWR sky130_fd_sc_hd__fill_2
XFILLER_63_329 VGND VGND VPWR VPWR sky130_fd_sc_hd__fill_4
XTAP_TAPCELL_ROW_3_160 VGND VPWR sky130_fd_sc_hd__tapvpwrvgnd_1
XFILLER_0_377 VPWR VGND VPWR VGND sky130_ef_sc_hd__decap_40_12
XFILLER_16_245 VGND VGND VPWR VPWR sky130_fd_sc_hd__fill_4
XFILLER_16_289 VPWR VGND VPWR VGND sky130_ef_sc_hd__decap_40_12
XFILLER_17_93 VPWR VGND VPWR VGND sky130_ef_sc_hd__decap_40_12
XFILLER_33_81 VPWR VGND VPWR VGND sky130_ef_sc_hd__decap_40_12
XANTENNA__315__A2 _283_/X VGND VGND VPWR VPWR sky130_fd_sc_hd__diode_2
XFILLER_39_359 VGND VGND VPWR VPWR sky130_fd_sc_hd__fill_1
XFILLER_3_193 VPWR VGND VPWR VGND sky130_ef_sc_hd__decap_40_12
XFILLER_12_3 VPWR VGND VPWR VGND sky130_ef_sc_hd__decap_40_12
XFILLER_54_307 VGND VGND VPWR VPWR sky130_fd_sc_hd__fill_1
XTAP_TAPCELL_ROW_17_262 VGND VPWR sky130_fd_sc_hd__tapvpwrvgnd_1
XTAP_TAPCELL_ROW_60_563 VGND VPWR sky130_fd_sc_hd__tapvpwrvgnd_1
XFILLER_22_237 VGND VGND VPWR VPWR sky130_fd_sc_hd__fill_2
XFILLER_57_167 VGND VGND VPWR VPWR sky130_fd_sc_hd__fill_1
XFILLER_38_15 VPWR VGND VPWR VGND sky130_ef_sc_hd__decap_40_12
XFILLER_53_373 VPWR VGND VPWR VGND sky130_ef_sc_hd__decap_40_12
XTAP_TAPCELL_ROW_0_141 VGND VPWR sky130_fd_sc_hd__tapvpwrvgnd_1
XTAP_TAPCELL_ROW_0_130 VGND VPWR sky130_fd_sc_hd__tapvpwrvgnd_1
XFILLER_13_237 VPWR VGND VPWR VGND sky130_ef_sc_hd__decap_40_12
XTAP_TAPCELL_ROW_23_298 VGND VPWR sky130_fd_sc_hd__tapvpwrvgnd_1
XFILLER_0_141 VPWR VGND VPWR VGND sky130_ef_sc_hd__decap_40_12
XFILLER_63_137 VPWR VGND VPWR VGND sky130_ef_sc_hd__decap_40_12
XFILLER_48_189 VGND VGND VPWR VPWR sky130_fd_sc_hd__fill_4
XANTENNA__297__A _485_/A VGND VGND VPWR VPWR sky130_fd_sc_hd__diode_2
XFILLER_28_81 VGND VGND VPWR VPWR sky130_fd_sc_hd__fill_2
X_498_ _565_/CLK _498_/D VGND VGND VPWR VPWR _498_/Q sky130_fd_sc_hd__dfxtp_1
XFILLER_39_167 VGND VGND VPWR VPWR sky130_fd_sc_hd__fill_1
XFILLER_54_137 VGND VGND VPWR VPWR sky130_fd_sc_hd__fill_2
XFILLER_50_365 VPWR VGND VPWR VGND sky130_ef_sc_hd__decap_40_12
XFILLER_50_321 VPWR VGND VPWR VGND sky130_ef_sc_hd__decap_40_12
XFILLER_40_27 VGND VGND VPWR VPWR sky130_fd_sc_hd__fill_1
XTAP_TAPCELL_ROW_20_279 VGND VPWR sky130_fd_sc_hd__tapvpwrvgnd_1
XFILLER_49_69 VPWR VGND VPWR VGND sky130_ef_sc_hd__decap_40_12
XFILLER_45_137 VPWR VGND VPWR VGND sky130_ef_sc_hd__decap_40_12
X_421_ _421_/A _421_/B _535_/Q _421_/D VGND VGND VPWR VPWR _427_/C sky130_fd_sc_hd__and4_1
XTAP_TAPCELL_ROW_28_335 VGND VPWR sky130_fd_sc_hd__tapvpwrvgnd_1
XFILLER_18_329 VPWR VGND VPWR VGND sky130_ef_sc_hd__decap_40_12
XFILLER_53_181 VPWR VGND VPWR VGND sky130_ef_sc_hd__decap_40_12
X_283_ _390_/C _390_/D _283_/C _283_/D VGND VGND VPWR VPWR _283_/X sky130_fd_sc_hd__or4_4
XTAP_TAPCELL_ROW_36_390 VGND VPWR sky130_fd_sc_hd__tapvpwrvgnd_1
X_352_ hold54/X _374_/A _337_/B _351_/X VGND VGND VPWR VPWR _352_/X sky130_fd_sc_hd__o211a_1
XFILLER_14_83 VGND VGND VPWR VPWR sky130_fd_sc_hd__fill_1
XFILLER_5_277 VGND VGND VPWR VPWR sky130_fd_sc_hd__fill_2
XFILLER_36_137 VGND VGND VPWR VPWR sky130_fd_sc_hd__fill_2
XFILLER_17_373 VPWR VGND VPWR VGND sky130_ef_sc_hd__decap_40_12
XFILLER_35_27 VPWR VGND VPWR VGND sky130_ef_sc_hd__decap_40_12
XFILLER_27_137 VPWR VGND VPWR VGND sky130_ef_sc_hd__decap_40_12
XFILLER_19_39 VPWR VGND VPWR VGND sky130_ef_sc_hd__decap_40_12
XFILLER_51_15 VPWR VGND VPWR VGND sky130_ef_sc_hd__decap_40_12
XFILLER_50_195 VGND VGND VPWR VPWR sky130_fd_sc_hd__fill_1
XTAP_TAPCELL_ROW_33_371 VGND VPWR sky130_fd_sc_hd__tapvpwrvgnd_1
XTAP_TAPCELL_ROW_25_316 VGND VPWR sky130_fd_sc_hd__tapvpwrvgnd_1
XFILLER_58_251 VGND VGND VPWR VPWR sky130_fd_sc_hd__fill_1
XFILLER_61_405 VGND VGND VPWR VPWR sky130_fd_sc_hd__fill_2
X_404_ _403_/A _402_/A _428_/A VGND VGND VPWR VPWR _404_/Y sky130_fd_sc_hd__o21ai_1
XFILLER_14_321 VPWR VGND VPWR VGND sky130_ef_sc_hd__decap_40_12
XFILLER_14_365 VPWR VGND VPWR VGND sky130_ef_sc_hd__decap_40_12
XFILLER_18_137 VGND VGND VPWR VPWR sky130_fd_sc_hd__fill_2
XFILLER_41_173 VGND VGND VPWR VPWR sky130_fd_sc_hd__fill_2
XFILLER_41_81 VPWR VGND VPWR VGND sky130_ef_sc_hd__decap_40_12
X_266_ _539_/Q _537_/Q _536_/Q _538_/Q VGND VGND VPWR VPWR _268_/C sky130_fd_sc_hd__or4bb_1
X_335_ _486_/Q _306_/B _332_/S _504_/Q VGND VGND VPWR VPWR _335_/X sky130_fd_sc_hd__a22o_1
XFILLER_25_93 VPWR VGND VPWR VGND sky130_ef_sc_hd__decap_40_12
XFILLER_64_265 VPWR VGND VPWR VGND sky130_ef_sc_hd__decap_40_12
XFILLER_64_221 VGND VGND VPWR VPWR sky130_fd_sc_hd__fill_2
XFILLER_52_405 VGND VGND VPWR VPWR sky130_fd_sc_hd__fill_2
XFILLER_49_273 VGND VGND VPWR VPWR sky130_fd_sc_hd__fill_4
XANTENNA__485__A _485_/A VGND VGND VPWR VPWR sky130_fd_sc_hd__diode_2
XFILLER_2_97 VPWR VGND VPWR VGND sky130_ef_sc_hd__decap_40_12
XFILLER_2_53 VPWR VGND VPWR VGND sky130_ef_sc_hd__decap_40_12
XPHY_EDGE_ROW_10_Right_10 VGND VGND VPWR VPWR sky130_fd_sc_hd__decap_3
XFILLER_32_195 VGND VGND VPWR VPWR sky130_fd_sc_hd__fill_1
XFILLER_17_181 VPWR VGND VPWR VGND sky130_ef_sc_hd__decap_40_12
XTAP_TAPCELL_ROW_30_352 VGND VPWR sky130_fd_sc_hd__tapvpwrvgnd_1
XFILLER_9_391 VGND VGND VPWR VPWR sky130_fd_sc_hd__fill_1
XFILLER_46_15 VPWR VGND VPWR VGND sky130_ef_sc_hd__decap_40_12
XFILLER_55_221 VGND VGND VPWR VPWR sky130_fd_sc_hd__fill_2
XFILLER_43_405 VGND VGND VPWR VPWR sky130_fd_sc_hd__fill_2
XANTENNA__354__B1 _337_/B VGND VGND VPWR VPWR sky130_fd_sc_hd__diode_2
XFILLER_7_317 VPWR VGND VPWR VGND sky130_ef_sc_hd__decap_40_12
XFILLER_11_335 VGND VGND VPWR VPWR sky130_fd_sc_hd__fill_1
XFILLER_11_51 VGND VGND VPWR VPWR sky130_fd_sc_hd__fill_4
XFILLER_46_265 VPWR VGND VPWR VGND sky130_ef_sc_hd__decap_40_12
XFILLER_46_221 VPWR VGND VPWR VGND sky130_ef_sc_hd__decap_40_12
XANTENNA__289__B _337_/B VGND VGND VPWR VPWR sky130_fd_sc_hd__diode_2
XFILLER_61_279 VGND VGND VPWR VPWR sky130_fd_sc_hd__fill_1
XFILLER_36_81 VGND VGND VPWR VPWR sky130_fd_sc_hd__fill_2
XFILLER_14_195 VGND VGND VPWR VPWR sky130_fd_sc_hd__fill_1
X_318_ _333_/A _318_/B VGND VGND VPWR VPWR _318_/X sky130_fd_sc_hd__or2_1
X_249_ _434_/A VGND VGND VPWR VPWR _293_/B sky130_fd_sc_hd__inv_2
XFILLER_6_361 VGND VGND VPWR VPWR sky130_fd_sc_hd__fill_2
XFILLER_42_3 VPWR VGND VPWR VGND sky130_ef_sc_hd__decap_40_12
XANTENNA_clkbuf_3_6__f_clk_A clkbuf_0_clk/X VGND VGND VPWR VPWR sky130_fd_sc_hd__diode_2
XFILLER_37_254 VGND VGND VPWR VPWR sky130_fd_sc_hd__fill_2
XFILLER_37_243 VGND VGND VPWR VPWR sky130_fd_sc_hd__fill_2
XFILLER_37_221 VGND VGND VPWR VPWR sky130_fd_sc_hd__fill_2
XFILLER_16_29 VPWR VGND VPWR VGND sky130_ef_sc_hd__decap_40_12
XFILLER_20_121 VPWR VGND VPWR VGND sky130_ef_sc_hd__decap_40_12
XFILLER_20_165 VPWR VGND VPWR VGND sky130_ef_sc_hd__decap_40_12
XFILLER_4_309 VPWR VGND VPWR VGND sky130_ef_sc_hd__decap_40_12
XTAP_TAPCELL_ROW_58_547 VGND VPWR sky130_fd_sc_hd__tapvpwrvgnd_1
XFILLER_57_69 VPWR VGND VPWR VGND sky130_ef_sc_hd__decap_40_12
XFILLER_16_405 VGND VGND VPWR VPWR sky130_fd_sc_hd__fill_2
XTAP_TAPCELL_ROW_41_425 VGND VPWR sky130_fd_sc_hd__tapvpwrvgnd_1
XFILLER_7_125 VPWR VGND VPWR VGND sky130_ef_sc_hd__decap_40_12
XFILLER_7_169 VPWR VGND VPWR VGND sky130_ef_sc_hd__decap_40_12
XFILLER_11_165 VGND VGND VPWR VPWR sky130_fd_sc_hd__fill_2
XFILLER_22_83 VGND VGND VPWR VPWR sky130_fd_sc_hd__fill_1
XFILLER_34_235 VGND VGND VPWR VPWR sky130_fd_sc_hd__fill_1
XTAP_TAPCELL_ROW_6_180 VGND VPWR sky130_fd_sc_hd__tapvpwrvgnd_1
XFILLER_19_221 VGND VGND VPWR VPWR sky130_fd_sc_hd__fill_2
XFILLER_8_41 VPWR VGND VPWR VGND sky130_ef_sc_hd__decap_40_12
XFILLER_8_85 VPWR VGND VPWR VGND sky130_ef_sc_hd__decap_40_12
XFILLER_57_349 VPWR VGND VPWR VGND sky130_ef_sc_hd__decap_40_12
XFILLER_57_305 VPWR VGND VPWR VGND sky130_ef_sc_hd__decap_40_12
XFILLER_27_39 VPWR VGND VPWR VGND sky130_ef_sc_hd__decap_40_12
XTAP_TAPCELL_ROW_63_583 VGND VPWR sky130_fd_sc_hd__tapvpwrvgnd_1
XTAP_TAPCELL_ROW_55_528 VGND VPWR sky130_fd_sc_hd__tapvpwrvgnd_1
XFILLER_43_27 VPWR VGND VPWR VGND sky130_ef_sc_hd__decap_40_12
XFILLER_25_257 VGND VGND VPWR VPWR sky130_fd_sc_hd__fill_1
XFILLER_4_139 VGND VGND VPWR VPWR sky130_fd_sc_hd__fill_1
XFILLER_48_305 VGND VGND VPWR VPWR sky130_fd_sc_hd__fill_2
XFILLER_0_389 VGND VGND VPWR VPWR sky130_fd_sc_hd__fill_2
XTAP_TAPCELL_ROW_3_161 VGND VPWR sky130_fd_sc_hd__tapvpwrvgnd_1
XPHY_EDGE_ROW_9_Left_74 VGND VGND VPWR VPWR sky130_fd_sc_hd__decap_3
XFILLER_33_93 VPWR VGND VPWR VGND sky130_ef_sc_hd__decap_40_12
XFILLER_8_401 VGND VGND VPWR VPWR sky130_fd_sc_hd__fill_4
XFILLER_3_161 VGND VGND VPWR VPWR sky130_fd_sc_hd__fill_4
XFILLER_39_349 VGND VGND VPWR VPWR sky130_fd_sc_hd__fill_1
Xhold1 hold1/A VGND VGND VPWR VPWR hold1/X sky130_fd_sc_hd__dlygate4sd3_1
XFILLER_62_363 VGND VGND VPWR VPWR sky130_fd_sc_hd__fill_1
XFILLER_47_393 VPWR VGND VPWR VGND sky130_ef_sc_hd__decap_40_12
XPHY_EDGE_ROW_8_Right_8 VGND VGND VPWR VPWR sky130_fd_sc_hd__decap_3
XPHY_EDGE_ROW_39_Right_39 VGND VGND VPWR VPWR sky130_fd_sc_hd__decap_3
XFILLER_38_27 VGND VGND VPWR VPWR sky130_fd_sc_hd__fill_1
XFILLER_1_109 VGND VGND VPWR VPWR sky130_fd_sc_hd__fill_2
XFILLER_57_113 VPWR VGND VPWR VGND sky130_ef_sc_hd__decap_40_12
XFILLER_54_15 VPWR VGND VPWR VGND sky130_ef_sc_hd__decap_40_12
XTAP_TAPCELL_ROW_0_142 VGND VPWR sky130_fd_sc_hd__tapvpwrvgnd_1
XTAP_TAPCELL_ROW_0_131 VGND VPWR sky130_fd_sc_hd__tapvpwrvgnd_1
XFILLER_53_385 VGND VGND VPWR VPWR sky130_fd_sc_hd__fill_4
XPHY_EDGE_ROW_48_Right_48 VGND VGND VPWR VPWR sky130_fd_sc_hd__decap_3
XANTENNA_fanout12_A _337_/B VGND VGND VPWR VPWR sky130_fd_sc_hd__diode_2
XFILLER_13_205 VPWR VGND VPWR VGND sky130_ef_sc_hd__decap_40_12
XFILLER_13_249 VPWR VGND VPWR VGND sky130_ef_sc_hd__decap_40_12
XFILLER_21_271 VGND VGND VPWR VPWR sky130_fd_sc_hd__fill_2
XPHY_EDGE_ROW_57_Right_57 VGND VGND VPWR VPWR sky130_fd_sc_hd__decap_3
XTAP_TAPCELL_ROW_23_299 VGND VPWR sky130_fd_sc_hd__tapvpwrvgnd_1
XFILLER_0_153 VPWR VGND VPWR VGND sky130_ef_sc_hd__decap_40_12
XFILLER_0_197 VPWR VGND VPWR VGND sky130_ef_sc_hd__decap_40_12
XFILLER_63_149 VPWR VGND VPWR VGND sky130_ef_sc_hd__decap_40_12
XFILLER_63_105 VGND VGND VPWR VPWR sky130_fd_sc_hd__fill_4
XFILLER_44_363 VGND VGND VPWR VPWR sky130_fd_sc_hd__fill_1
XFILLER_44_81 VGND VGND VPWR VPWR sky130_fd_sc_hd__fill_2
X_497_ _545_/CLK _497_/D VGND VGND VPWR VPWR _497_/Q sky130_fd_sc_hd__dfxtp_1
XFILLER_8_253 VPWR VGND VPWR VGND sky130_ef_sc_hd__decap_40_12
XFILLER_39_113 VPWR VGND VPWR VGND sky130_ef_sc_hd__decap_40_12
XFILLER_27_319 VGND VGND VPWR VPWR sky130_fd_sc_hd__fill_2
XFILLER_62_193 VGND VGND VPWR VPWR sky130_fd_sc_hd__fill_2
XPHY_EDGE_ROW_59_Left_124 VGND VGND VPWR VPWR sky130_fd_sc_hd__decap_3
XFILLER_50_377 VPWR VGND VPWR VGND sky130_ef_sc_hd__decap_40_12
XFILLER_50_333 VPWR VGND VPWR VGND sky130_ef_sc_hd__decap_40_12
XFILLER_24_29 VPWR VGND VPWR VGND sky130_ef_sc_hd__decap_40_12
XFILLER_49_15 VPWR VGND VPWR VGND sky130_ef_sc_hd__decap_40_12
XFILLER_53_193 VPWR VGND VPWR VGND sky130_ef_sc_hd__decap_40_12
XFILLER_45_149 VPWR VGND VPWR VGND sky130_ef_sc_hd__decap_40_12
XFILLER_45_105 VGND VGND VPWR VPWR sky130_fd_sc_hd__fill_4
X_420_ _420_/A _420_/B VGND VGND VPWR VPWR _420_/Y sky130_fd_sc_hd__nor2_1
X_351_ _390_/B _511_/Q VGND VGND VPWR VPWR _351_/X sky130_fd_sc_hd__or2_1
XTAP_TAPCELL_ROW_28_336 VGND VPWR sky130_fd_sc_hd__tapvpwrvgnd_1
X_282_ _255_/X _260_/X _281_/X _374_/A VGND VGND VPWR VPWR _306_/B sky130_fd_sc_hd__a211oi_4
XTAP_TAPCELL_ROW_36_391 VGND VPWR sky130_fd_sc_hd__tapvpwrvgnd_1
XTAP_TAPCELL_ROW_11_214 VGND VPWR sky130_fd_sc_hd__tapvpwrvgnd_1
XFILLER_30_83 VGND VGND VPWR VPWR sky130_fd_sc_hd__fill_1
XFILLER_5_223 VGND VGND VPWR VPWR sky130_fd_sc_hd__fill_1
XFILLER_39_81 VPWR VGND VPWR VGND sky130_ef_sc_hd__decap_40_12
XFILLER_44_193 VGND VGND VPWR VPWR sky130_fd_sc_hd__fill_2
XFILLER_17_385 VGND VGND VPWR VPWR sky130_fd_sc_hd__fill_4
X_549_ _565_/CLK _549_/D VGND VGND VPWR VPWR _549_/Q sky130_fd_sc_hd__dfxtp_1
XFILLER_35_39 VPWR VGND VPWR VGND sky130_ef_sc_hd__decap_40_12
XFILLER_27_149 VPWR VGND VPWR VGND sky130_ef_sc_hd__decap_40_12
XFILLER_27_105 VGND VGND VPWR VPWR sky130_fd_sc_hd__fill_4
XTAP_TAPCELL_ROW_25_317 VGND VPWR sky130_fd_sc_hd__tapvpwrvgnd_1
XFILLER_51_27 VPWR VGND VPWR VGND sky130_ef_sc_hd__decap_40_12
XFILLER_50_141 VPWR VGND VPWR VGND sky130_ef_sc_hd__decap_40_12
XTAP_TAPCELL_ROW_33_372 VGND VPWR sky130_fd_sc_hd__tapvpwrvgnd_1
XFILLER_23_333 VGND VGND VPWR VPWR sky130_fd_sc_hd__fill_2
XFILLER_23_355 VGND VGND VPWR VPWR sky130_fd_sc_hd__fill_1
X_334_ hold74/X _337_/C _333_/X _273_/A VGND VGND VPWR VPWR _334_/X sky130_fd_sc_hd__o211a_1
X_403_ _403_/A _403_/B _403_/C _403_/D VGND VGND VPWR VPWR _412_/D sky130_fd_sc_hd__and4_1
XFILLER_14_333 VPWR VGND VPWR VGND sky130_ef_sc_hd__decap_40_12
XFILLER_14_377 VPWR VGND VPWR VGND sky130_ef_sc_hd__decap_40_12
XFILLER_41_93 VPWR VGND VPWR VGND sky130_ef_sc_hd__decap_40_12
X_265_ _268_/A _265_/B _265_/C _265_/D VGND VGND VPWR VPWR _387_/B sky130_fd_sc_hd__nor4_1
XFILLER_1_281 VPWR VGND VPWR VGND sky130_ef_sc_hd__decap_40_12
XPHY_EDGE_ROW_22_Left_87 VGND VGND VPWR VPWR sky130_fd_sc_hd__decap_3
XFILLER_64_277 VGND VGND VPWR VPWR sky130_fd_sc_hd__fill_2
XFILLER_2_65 VPWR VGND VPWR VGND sky130_ef_sc_hd__decap_40_12
XFILLER_32_141 VPWR VGND VPWR VGND sky130_ef_sc_hd__decap_40_12
XTAP_TAPCELL_ROW_30_353 VGND VPWR sky130_fd_sc_hd__tapvpwrvgnd_1
XFILLER_17_193 VPWR VGND VPWR VGND sky130_ef_sc_hd__decap_40_12
XFILLER_20_358 VGND VGND VPWR VPWR sky130_fd_sc_hd__fill_4
XFILLER_46_27 VGND VGND VPWR VPWR sky130_fd_sc_hd__fill_1
XFILLER_62_15 VPWR VGND VPWR VGND sky130_ef_sc_hd__decap_40_12
XFILLER_55_277 VGND VGND VPWR VPWR sky130_fd_sc_hd__fill_2
XFILLER_7_329 VGND VGND VPWR VPWR sky130_fd_sc_hd__fill_4
XFILLER_2_3 VPWR VGND VPWR VGND sky130_ef_sc_hd__decap_40_12
XFILLER_61_225 VPWR VGND VPWR VGND sky130_ef_sc_hd__decap_40_12
XFILLER_46_299 VGND VGND VPWR VPWR sky130_fd_sc_hd__fill_8
XFILLER_46_288 VGND VGND VPWR VPWR sky130_fd_sc_hd__fill_2
XFILLER_46_277 VGND VGND VPWR VPWR sky130_fd_sc_hd__fill_2
XFILLER_46_233 VPWR VGND VPWR VGND sky130_ef_sc_hd__decap_40_12
XFILLER_34_406 VGND VGND VPWR VPWR sky130_fd_sc_hd__fill_1
XFILLER_52_81 VGND VGND VPWR VPWR sky130_fd_sc_hd__fill_2
XTAP_TAPCELL_ROW_44_445 VGND VPWR sky130_fd_sc_hd__tapvpwrvgnd_1
X_317_ hold92/X _498_/Q _332_/S VGND VGND VPWR VPWR _318_/B sky130_fd_sc_hd__mux2_1
XFILLER_14_141 VPWR VGND VPWR VGND sky130_ef_sc_hd__decap_40_12
X_248_ _447_/B VGND VGND VPWR VPWR _248_/Y sky130_fd_sc_hd__inv_2
XFILLER_35_3 VPWR VGND VPWR VGND sky130_ef_sc_hd__decap_40_12
XFILLER_37_277 VGND VGND VPWR VPWR sky130_fd_sc_hd__fill_2
XFILLER_32_29 VPWR VGND VPWR VGND sky130_ef_sc_hd__decap_40_12
XFILLER_20_133 VGND VGND VPWR VPWR sky130_fd_sc_hd__fill_4
XFILLER_20_177 VPWR VGND VPWR VGND sky130_ef_sc_hd__decap_40_12
XFILLER_57_15 VPWR VGND VPWR VGND sky130_ef_sc_hd__decap_40_12
XTAP_TAPCELL_ROW_58_548 VGND VPWR sky130_fd_sc_hd__tapvpwrvgnd_1
XFILLER_28_244 VGND VGND VPWR VPWR sky130_fd_sc_hd__fill_4
XTAP_TAPCELL_ROW_41_426 VGND VPWR sky130_fd_sc_hd__tapvpwrvgnd_1
XFILLER_11_111 VGND VGND VPWR VPWR sky130_fd_sc_hd__fill_1
XFILLER_7_137 VPWR VGND VPWR VGND sky130_ef_sc_hd__decap_40_12
XFILLER_59_391 VGND VGND VPWR VPWR sky130_fd_sc_hd__fill_1
XTAP_TAPCELL_ROW_6_181 VGND VPWR sky130_fd_sc_hd__tapvpwrvgnd_1
XFILLER_47_81 VPWR VGND VPWR VGND sky130_ef_sc_hd__decap_40_12
XFILLER_34_269 VGND VGND VPWR VPWR sky130_fd_sc_hd__fill_1
XFILLER_8_53 VPWR VGND VPWR VGND sky130_ef_sc_hd__decap_40_12
XFILLER_8_97 VPWR VGND VPWR VGND sky130_ef_sc_hd__decap_40_12
XFILLER_57_317 VPWR VGND VPWR VGND sky130_ef_sc_hd__decap_40_12
XPHY_EDGE_ROW_40_Left_105 VGND VGND VPWR VPWR sky130_fd_sc_hd__decap_3
XPHY_EDGE_ROW_25_Left_90 VGND VGND VPWR VPWR sky130_fd_sc_hd__decap_3
XTAP_TAPCELL_ROW_63_584 VGND VPWR sky130_fd_sc_hd__tapvpwrvgnd_1
XFILLER_43_39 VPWR VGND VPWR VGND sky130_ef_sc_hd__decap_40_12
XFILLER_25_225 VPWR VGND VPWR VGND sky130_ef_sc_hd__decap_40_12
XFILLER_0_335 VGND VGND VPWR VPWR sky130_fd_sc_hd__fill_1
XFILLER_56_361 VGND VGND VPWR VPWR sky130_fd_sc_hd__fill_2
XTAP_TAPCELL_ROW_3_162 VGND VPWR sky130_fd_sc_hd__tapvpwrvgnd_1
XFILLER_17_51 VGND VGND VPWR VPWR sky130_fd_sc_hd__fill_4
XFILLER_24_280 VGND VGND VPWR VPWR sky130_fd_sc_hd__fill_2
XFILLER_54_309 VPWR VGND VPWR VGND sky130_ef_sc_hd__decap_40_12
XFILLER_47_361 VPWR VGND VPWR VGND sky130_ef_sc_hd__decap_40_12
XFILLER_39_306 VGND VGND VPWR VPWR sky130_fd_sc_hd__fill_8
Xhold2 hold2/A VGND VGND VPWR VPWR hold2/X sky130_fd_sc_hd__dlygate4sd3_1
XFILLER_22_239 VGND VGND VPWR VPWR sky130_fd_sc_hd__fill_1
XFILLER_30_250 VGND VGND VPWR VPWR sky130_fd_sc_hd__fill_2
XFILLER_57_125 VPWR VGND VPWR VGND sky130_ef_sc_hd__decap_40_12
XFILLER_57_169 VPWR VGND VPWR VGND sky130_ef_sc_hd__decap_40_12
XFILLER_54_27 VGND VGND VPWR VPWR sky130_fd_sc_hd__fill_1
XTAP_TAPCELL_ROW_0_143 VGND VPWR sky130_fd_sc_hd__tapvpwrvgnd_1
XTAP_TAPCELL_ROW_0_132 VGND VPWR sky130_fd_sc_hd__tapvpwrvgnd_1
XFILLER_13_217 VGND VGND VPWR VPWR sky130_fd_sc_hd__fill_4
XFILLER_21_250 VGND VGND VPWR VPWR sky130_fd_sc_hd__fill_1
XFILLER_5_405 VGND VGND VPWR VPWR sky130_fd_sc_hd__fill_2
XFILLER_36_309 VGND VGND VPWR VPWR sky130_fd_sc_hd__fill_2
XFILLER_28_83 VGND VGND VPWR VPWR sky130_fd_sc_hd__fill_1
XFILLER_0_165 VGND VGND VPWR VPWR sky130_fd_sc_hd__fill_2
X_496_ _539_/CLK _496_/D VGND VGND VPWR VPWR hold9/A sky130_fd_sc_hd__dfxtp_1
X_565_ _565_/CLK _565_/D VGND VGND VPWR VPWR _565_/Q sky130_fd_sc_hd__dfxtp_1
XFILLER_60_81 VGND VGND VPWR VPWR sky130_fd_sc_hd__fill_2
XFILLER_8_221 VPWR VGND VPWR VGND sky130_ef_sc_hd__decap_40_12
XFILLER_8_265 VPWR VGND VPWR VGND sky130_ef_sc_hd__decap_40_12
XFILLER_39_125 VPWR VGND VPWR VGND sky130_ef_sc_hd__decap_40_12
XFILLER_54_139 VGND VGND VPWR VPWR sky130_fd_sc_hd__fill_1
XFILLER_39_169 VGND VGND VPWR VPWR sky130_fd_sc_hd__fill_2
XFILLER_50_389 VPWR VGND VPWR VGND sky130_ef_sc_hd__decap_40_12
XFILLER_50_345 VPWR VGND VPWR VGND sky130_ef_sc_hd__decap_40_12
XFILLER_50_301 VGND VGND VPWR VPWR sky130_fd_sc_hd__fill_4
XFILLER_10_209 VPWR VGND VPWR VGND sky130_ef_sc_hd__decap_40_12
XFILLER_49_27 VPWR VGND VPWR VGND sky130_ef_sc_hd__decap_40_12
XFILLER_40_29 VPWR VGND VPWR VGND sky130_ef_sc_hd__decap_40_12
XFILLER_58_401 VGND VGND VPWR VPWR sky130_fd_sc_hd__fill_4
XFILLER_60_109 VPWR VGND VPWR VGND sky130_ef_sc_hd__decap_40_12
XFILLER_53_161 VGND VGND VPWR VPWR sky130_fd_sc_hd__fill_4
XFILLER_41_334 VGND VGND VPWR VPWR sky130_fd_sc_hd__fill_2
XFILLER_38_191 VGND VGND VPWR VPWR sky130_fd_sc_hd__fill_1
XTAP_TAPCELL_ROW_36_392 VGND VPWR sky130_fd_sc_hd__tapvpwrvgnd_1
X_350_ _368_/A _374_/A _337_/B _349_/X VGND VGND VPWR VPWR _350_/X sky130_fd_sc_hd__o211a_1
XTAP_TAPCELL_ROW_28_337 VGND VPWR sky130_fd_sc_hd__tapvpwrvgnd_1
X_281_ _390_/C _390_/D _283_/D VGND VGND VPWR VPWR _281_/X sky130_fd_sc_hd__or3_1
XTAP_TAPCELL_ROW_11_215 VGND VPWR sky130_fd_sc_hd__tapvpwrvgnd_1
XFILLER_14_41 VPWR VGND VPWR VGND sky130_ef_sc_hd__decap_40_12
XFILLER_14_85 VPWR VGND VPWR VGND sky130_ef_sc_hd__decap_40_12
XFILLER_5_279 VGND VGND VPWR VPWR sky130_fd_sc_hd__fill_1
XFILLER_55_81 VPWR VGND VPWR VGND sky130_ef_sc_hd__decap_40_12
XFILLER_51_109 VGND VGND VPWR VPWR sky130_fd_sc_hd__fill_2
XFILLER_39_93 VPWR VGND VPWR VGND sky130_ef_sc_hd__decap_40_12
XFILLER_36_139 VGND VGND VPWR VPWR sky130_fd_sc_hd__fill_1
XFILLER_32_389 VGND VGND VPWR VPWR sky130_fd_sc_hd__fill_1
X_479_ _480_/B _480_/C _480_/A VGND VGND VPWR VPWR _479_/X sky130_fd_sc_hd__a21o_1
X_548_ _565_/CLK _548_/D VGND VGND VPWR VPWR _548_/Q sky130_fd_sc_hd__dfxtp_1
XFILLER_42_109 VPWR VGND VPWR VGND sky130_ef_sc_hd__decap_40_12
XTAP_TAPCELL_ROW_25_318 VGND VPWR sky130_fd_sc_hd__tapvpwrvgnd_1
XFILLER_23_312 VGND VGND VPWR VPWR sky130_fd_sc_hd__fill_1
XFILLER_51_39 VPWR VGND VPWR VGND sky130_ef_sc_hd__decap_40_12
XFILLER_50_197 VPWR VGND VPWR VGND sky130_ef_sc_hd__decap_40_12
XFILLER_50_153 VPWR VGND VPWR VGND sky130_ef_sc_hd__decap_40_12
XTAP_TAPCELL_ROW_33_373 VGND VPWR sky130_fd_sc_hd__tapvpwrvgnd_1
XFILLER_2_249 VGND VGND VPWR VPWR sky130_fd_sc_hd__fill_2
XFILLER_58_253 VPWR VGND VPWR VGND sky130_ef_sc_hd__decap_40_12
XFILLER_33_109 VGND VGND VPWR VPWR sky130_fd_sc_hd__fill_2
XFILLER_18_139 VGND VGND VPWR VPWR sky130_fd_sc_hd__fill_1
XFILLER_41_186 VGND VGND VPWR VPWR sky130_fd_sc_hd__fill_1
X_264_ _536_/Q _534_/Q _535_/Q _537_/Q VGND VGND VPWR VPWR _265_/D sky130_fd_sc_hd__or4bb_1
X_333_ _333_/A _333_/B VGND VGND VPWR VPWR _333_/X sky130_fd_sc_hd__or2_1
X_402_ _402_/A _402_/B VGND VGND VPWR VPWR _402_/Y sky130_fd_sc_hd__nor2_1
XFILLER_25_51 VGND VGND VPWR VPWR sky130_fd_sc_hd__fill_4
XFILLER_14_301 VGND VGND VPWR VPWR sky130_fd_sc_hd__fill_4
XFILLER_14_345 VPWR VGND VPWR VGND sky130_ef_sc_hd__decap_40_12
XFILLER_14_389 VPWR VGND VPWR VGND sky130_ef_sc_hd__decap_40_12
XFILLER_2_77 VGND VGND VPWR VPWR sky130_fd_sc_hd__fill_4
XFILLER_1_293 VPWR VGND VPWR VGND sky130_ef_sc_hd__decap_40_12
XFILLER_64_223 VGND VGND VPWR VPWR sky130_fd_sc_hd__fill_1
XFILLER_17_161 VGND VGND VPWR VPWR sky130_fd_sc_hd__fill_4
XFILLER_24_109 VPWR VGND VPWR VGND sky130_ef_sc_hd__decap_40_12
XFILLER_32_153 VGND VGND VPWR VPWR sky130_fd_sc_hd__fill_4
XFILLER_9_393 VPWR VGND VPWR VGND sky130_ef_sc_hd__decap_40_12
XFILLER_55_223 VGND VGND VPWR VPWR sky130_fd_sc_hd__fill_1
XFILLER_62_27 VGND VGND VPWR VPWR sky130_fd_sc_hd__fill_1
XFILLER_11_337 VPWR VGND VPWR VGND sky130_ef_sc_hd__decap_40_12
XFILLER_15_109 VGND VGND VPWR VPWR sky130_fd_sc_hd__fill_2
XFILLER_19_404 VGND VGND VPWR VPWR sky130_fd_sc_hd__fill_2
XFILLER_61_237 VPWR VGND VPWR VGND sky130_ef_sc_hd__decap_40_12
XFILLER_46_245 VGND VGND VPWR VPWR sky130_fd_sc_hd__fill_4
XTAP_TAPCELL_ROW_44_446 VGND VPWR sky130_fd_sc_hd__tapvpwrvgnd_1
XFILLER_36_83 VGND VGND VPWR VPWR sky130_fd_sc_hd__fill_1
X_316_ _434_/A _436_/B VGND VGND VPWR VPWR _332_/S sky130_fd_sc_hd__nand2_2
X_247_ _337_/B VGND VGND VPWR VPWR _485_/A sky130_fd_sc_hd__inv_4
XFILLER_14_153 VPWR VGND VPWR VGND sky130_ef_sc_hd__decap_40_12
XFILLER_14_197 VPWR VGND VPWR VGND sky130_ef_sc_hd__decap_40_12
XFILLER_6_363 VGND VGND VPWR VPWR sky130_fd_sc_hd__fill_1
XFILLER_37_256 VGND VGND VPWR VPWR sky130_fd_sc_hd__fill_1
XFILLER_37_223 VGND VGND VPWR VPWR sky130_fd_sc_hd__fill_1
XFILLER_37_212 VGND VGND VPWR VPWR sky130_fd_sc_hd__fill_1
XFILLER_28_3 VPWR VGND VPWR VGND sky130_ef_sc_hd__decap_40_12
XFILLER_20_189 VGND VGND VPWR VPWR sky130_fd_sc_hd__fill_4
XFILLER_57_27 VPWR VGND VPWR VGND sky130_ef_sc_hd__decap_40_12
XTAP_TAPCELL_ROW_58_549 VGND VPWR sky130_fd_sc_hd__tapvpwrvgnd_1
XFILLER_28_234 VGND VGND VPWR VPWR sky130_fd_sc_hd__fill_1
XFILLER_51_281 VPWR VGND VPWR VGND sky130_ef_sc_hd__decap_40_12
XTAP_TAPCELL_ROW_41_427 VGND VPWR sky130_fd_sc_hd__tapvpwrvgnd_1
XFILLER_7_105 VGND VGND VPWR VPWR sky130_fd_sc_hd__fill_4
XFILLER_11_167 VGND VGND VPWR VPWR sky130_fd_sc_hd__fill_1
XFILLER_22_41 VPWR VGND VPWR VGND sky130_ef_sc_hd__decap_40_12
XFILLER_3_333 VGND VGND VPWR VPWR sky130_fd_sc_hd__fill_2
XFILLER_7_149 VPWR VGND VPWR VGND sky130_ef_sc_hd__decap_40_12
XFILLER_22_85 VPWR VGND VPWR VGND sky130_ef_sc_hd__decap_40_12
XTAP_TAPCELL_ROW_6_182 VGND VPWR sky130_fd_sc_hd__tapvpwrvgnd_1
XFILLER_19_223 VGND VGND VPWR VPWR sky130_fd_sc_hd__fill_1
XFILLER_63_81 VPWR VGND VPWR VGND sky130_ef_sc_hd__decap_40_12
XFILLER_47_93 VPWR VGND VPWR VGND sky130_ef_sc_hd__decap_40_12
XFILLER_42_270 VGND VGND VPWR VPWR sky130_fd_sc_hd__fill_2
XFILLER_34_248 VGND VGND VPWR VPWR sky130_fd_sc_hd__fill_2
XFILLER_19_289 VGND VGND VPWR VPWR sky130_fd_sc_hd__fill_2
XFILLER_8_65 VPWR VGND VPWR VGND sky130_ef_sc_hd__decap_40_12
XFILLER_6_193 VGND VGND VPWR VPWR sky130_fd_sc_hd__fill_2
XFILLER_57_329 VGND VGND VPWR VPWR sky130_fd_sc_hd__fill_4
XFILLER_25_237 VGND VGND VPWR VPWR sky130_fd_sc_hd__fill_4
XANTENNA__309__A2 _283_/X VGND VGND VPWR VPWR sky130_fd_sc_hd__diode_2
XFILLER_48_307 VGND VGND VPWR VPWR sky130_fd_sc_hd__fill_1
XTAP_TAPCELL_ROW_3_163 VGND VPWR sky130_fd_sc_hd__tapvpwrvgnd_1
XFILLER_33_51 VGND VGND VPWR VPWR sky130_fd_sc_hd__fill_4
XFILLER_62_321 VPWR VGND VPWR VGND sky130_ef_sc_hd__decap_40_12
XFILLER_58_81 VGND VGND VPWR VPWR sky130_fd_sc_hd__fill_2
XFILLER_47_373 VPWR VGND VPWR VGND sky130_ef_sc_hd__decap_40_12
Xhold3 hold3/A VGND VGND VPWR VPWR hold3/X sky130_fd_sc_hd__dlygate4sd3_1
XFILLER_62_365 VPWR VGND VPWR VGND sky130_ef_sc_hd__decap_40_12
XFILLER_15_281 VPWR VGND VPWR VGND sky130_ef_sc_hd__decap_40_12
XFILLER_30_284 VPWR VGND VPWR VGND sky130_ef_sc_hd__decap_40_12
XFILLER_57_137 VPWR VGND VPWR VGND sky130_ef_sc_hd__decap_40_12
XFILLER_38_29 VPWR VGND VPWR VGND sky130_ef_sc_hd__decap_40_12
XTAP_TAPCELL_ROW_51_500 VGND VPWR sky130_fd_sc_hd__tapvpwrvgnd_1
XTAP_TAPCELL_ROW_0_133 VGND VPWR sky130_fd_sc_hd__tapvpwrvgnd_1
XFILLER_0_111 VGND VGND VPWR VPWR sky130_fd_sc_hd__fill_1
XFILLER_48_137 VGND VGND VPWR VPWR sky130_fd_sc_hd__fill_2
XFILLER_44_321 VPWR VGND VPWR VGND sky130_ef_sc_hd__decap_40_12
XFILLER_44_365 VPWR VGND VPWR VGND sky130_ef_sc_hd__decap_40_12
XFILLER_44_83 VGND VGND VPWR VPWR sky130_fd_sc_hd__fill_1
X_495_ _516_/CLK hold4/X VGND VGND VPWR VPWR hold3/A sky130_fd_sc_hd__dfxtp_1
X_564_ _564_/CLK _564_/D VGND VGND VPWR VPWR _564_/Q sky130_fd_sc_hd__dfxtp_1
XFILLER_12_251 VGND VGND VPWR VPWR sky130_fd_sc_hd__fill_1
XTAP_TAPCELL_ROW_14_235 VGND VPWR sky130_fd_sc_hd__tapvpwrvgnd_1
XFILLER_5_55 VGND VGND VPWR VPWR sky130_fd_sc_hd__fill_1
XFILLER_8_233 VPWR VGND VPWR VGND sky130_ef_sc_hd__decap_40_12
XFILLER_8_277 VPWR VGND VPWR VGND sky130_ef_sc_hd__decap_40_12
XFILLER_39_137 VPWR VGND VPWR VGND sky130_ef_sc_hd__decap_40_12
XFILLER_10_3 VPWR VGND VPWR VGND sky130_ef_sc_hd__decap_40_12
XFILLER_47_181 VPWR VGND VPWR VGND sky130_ef_sc_hd__decap_40_12
XFILLER_62_195 VGND VGND VPWR VPWR sky130_fd_sc_hd__fill_1
XFILLER_50_357 VGND VGND VPWR VPWR sky130_fd_sc_hd__fill_4
XFILLER_49_39 VPWR VGND VPWR VGND sky130_ef_sc_hd__decap_40_12
XTAP_TAPCELL_ROW_28_338 VGND VPWR sky130_fd_sc_hd__tapvpwrvgnd_1
XTAP_TAPCELL_ROW_36_393 VGND VPWR sky130_fd_sc_hd__tapvpwrvgnd_1
X_280_ hold21/X _358_/A VGND VGND VPWR VPWR _283_/D sky130_fd_sc_hd__and2b_1
XFILLER_14_53 VPWR VGND VPWR VGND sky130_ef_sc_hd__decap_40_12
XFILLER_30_41 VPWR VGND VPWR VGND sky130_ef_sc_hd__decap_40_12
XFILLER_5_225 VPWR VGND VPWR VGND sky130_ef_sc_hd__decap_40_12
XTAP_TAPCELL_ROW_11_216 VGND VPWR sky130_fd_sc_hd__tapvpwrvgnd_1
XFILLER_14_97 VPWR VGND VPWR VGND sky130_ef_sc_hd__decap_40_12
XFILLER_30_85 VPWR VGND VPWR VGND sky130_ef_sc_hd__decap_40_12
XFILLER_64_405 VGND VGND VPWR VPWR sky130_fd_sc_hd__fill_2
XFILLER_55_93 VPWR VGND VPWR VGND sky130_ef_sc_hd__decap_40_12
XFILLER_32_302 VGND VGND VPWR VPWR sky130_fd_sc_hd__fill_1
X_547_ _565_/CLK _547_/D VGND VGND VPWR VPWR _547_/Q sky130_fd_sc_hd__dfxtp_1
XFILLER_44_195 VGND VGND VPWR VPWR sky130_fd_sc_hd__fill_1
XFILLER_40_390 VGND VGND VPWR VPWR sky130_fd_sc_hd__fill_1
X_478_ _480_/B _480_/C _477_/Y VGND VGND VPWR VPWR _478_/Y sky130_fd_sc_hd__a21oi_1
XFILLER_58_3 VPWR VGND VPWR VGND sky130_ef_sc_hd__decap_40_12
XFILLER_55_405 VGND VGND VPWR VPWR sky130_fd_sc_hd__fill_2
XFILLER_50_165 VPWR VGND VPWR VGND sky130_ef_sc_hd__decap_40_12
XFILLER_50_121 VPWR VGND VPWR VGND sky130_ef_sc_hd__decap_40_12
XFILLER_23_335 VGND VGND VPWR VPWR sky130_fd_sc_hd__fill_1
XTAP_TAPCELL_ROW_33_374 VGND VPWR sky130_fd_sc_hd__tapvpwrvgnd_1
XFILLER_58_221 VPWR VGND VPWR VGND sky130_ef_sc_hd__decap_40_12
XFILLER_58_265 VPWR VGND VPWR VGND sky130_ef_sc_hd__decap_40_12
XFILLER_46_405 VGND VGND VPWR VPWR sky130_fd_sc_hd__fill_2
X_401_ _403_/B _398_/X _428_/A VGND VGND VPWR VPWR _401_/Y sky130_fd_sc_hd__o21ai_1
XFILLER_41_165 VGND VGND VPWR VPWR sky130_fd_sc_hd__fill_2
X_263_ _531_/Q _528_/Q _529_/Q _530_/Q VGND VGND VPWR VPWR _268_/B sky130_fd_sc_hd__or4bb_1
X_332_ _504_/Q _503_/Q _332_/S VGND VGND VPWR VPWR _333_/B sky130_fd_sc_hd__mux2_1
XFILLER_14_357 VGND VGND VPWR VPWR sky130_fd_sc_hd__fill_4
XFILLER_22_390 VGND VGND VPWR VPWR sky130_fd_sc_hd__fill_1
XFILLER_41_51 VGND VGND VPWR VPWR sky130_fd_sc_hd__fill_4
XFILLER_49_221 VGND VGND VPWR VPWR sky130_fd_sc_hd__fill_2
XFILLER_1_261 VPWR VGND VPWR VGND sky130_ef_sc_hd__decap_40_12
XFILLER_64_279 VGND VGND VPWR VPWR sky130_fd_sc_hd__fill_1
XTAP_TAPCELL_ROW_47_466 VGND VPWR sky130_fd_sc_hd__tapvpwrvgnd_1
XFILLER_32_121 VPWR VGND VPWR VGND sky130_ef_sc_hd__decap_40_12
XFILLER_20_305 VGND VGND VPWR VPWR sky130_fd_sc_hd__fill_2
XANTENNA__348__B1 _337_/B VGND VGND VPWR VPWR sky130_fd_sc_hd__diode_2
XFILLER_9_361 VPWR VGND VPWR VGND sky130_ef_sc_hd__decap_40_12
XFILLER_55_279 VGND VGND VPWR VPWR sky130_fd_sc_hd__fill_1
XFILLER_46_29 VPWR VGND VPWR VGND sky130_ef_sc_hd__decap_40_12
XFILLER_11_305 VPWR VGND VPWR VGND sky130_ef_sc_hd__decap_40_12
XFILLER_11_349 VPWR VGND VPWR VGND sky130_ef_sc_hd__decap_40_12
XFILLER_23_165 VGND VGND VPWR VPWR sky130_fd_sc_hd__fill_2
XFILLER_61_249 VPWR VGND VPWR VGND sky130_ef_sc_hd__decap_40_12
XFILLER_61_205 VPWR VGND VPWR VGND sky130_ef_sc_hd__decap_40_12
XFILLER_46_279 VGND VGND VPWR VPWR sky130_fd_sc_hd__fill_1
XTAP_TAPCELL_ROW_44_447 VGND VPWR sky130_fd_sc_hd__tapvpwrvgnd_1
XANTENNA__290__A2 _337_/B VGND VGND VPWR VPWR sky130_fd_sc_hd__diode_2
XFILLER_14_121 VPWR VGND VPWR VGND sky130_ef_sc_hd__decap_40_12
XFILLER_52_83 VGND VGND VPWR VPWR sky130_fd_sc_hd__fill_1
X_246_ _390_/D VGND VGND VPWR VPWR _374_/B sky130_fd_sc_hd__inv_2
X_315_ hold15/X _283_/X _314_/X VGND VGND VPWR VPWR _315_/X sky130_fd_sc_hd__a21o_1
XFILLER_14_165 VPWR VGND VPWR VGND sky130_ef_sc_hd__decap_40_12
XFILLER_37_279 VGND VGND VPWR VPWR sky130_fd_sc_hd__fill_1
XFILLER_37_202 VGND VGND VPWR VPWR sky130_fd_sc_hd__fill_2
XFILLER_52_249 VGND VGND VPWR VPWR sky130_fd_sc_hd__fill_2
XFILLER_57_39 VPWR VGND VPWR VGND sky130_ef_sc_hd__decap_40_12
XFILLER_43_227 VPWR VGND VPWR VGND sky130_ef_sc_hd__decap_40_12
XFILLER_51_293 VPWR VGND VPWR VGND sky130_ef_sc_hd__decap_40_12
XTAP_TAPCELL_ROW_41_428 VGND VPWR sky130_fd_sc_hd__tapvpwrvgnd_1
XFILLER_11_113 VPWR VGND VPWR VGND sky130_ef_sc_hd__decap_40_12
XFILLER_22_53 VPWR VGND VPWR VGND sky130_ef_sc_hd__decap_40_12
XFILLER_3_389 VGND VGND VPWR VPWR sky130_fd_sc_hd__fill_2
XFILLER_22_97 VPWR VGND VPWR VGND sky130_ef_sc_hd__decap_40_12
XFILLER_59_393 VPWR VGND VPWR VGND sky130_ef_sc_hd__decap_40_12
XTAP_TAPCELL_ROW_6_183 VGND VPWR sky130_fd_sc_hd__tapvpwrvgnd_1
XFILLER_63_93 VPWR VGND VPWR VGND sky130_ef_sc_hd__decap_40_12
Xclkbuf_3_4__f_clk clkbuf_0_clk/X VGND VGND VPWR VPWR _564_/CLK sky130_fd_sc_hd__clkbuf_16
XFILLER_8_77 VGND VGND VPWR VPWR sky130_fd_sc_hd__fill_4
XFILLER_40_3 VPWR VGND VPWR VGND sky130_ef_sc_hd__decap_40_12
XFILLER_40_219 VGND VGND VPWR VPWR sky130_fd_sc_hd__fill_4
XFILLER_4_109 VPWR VGND VPWR VGND sky130_ef_sc_hd__decap_40_12
XFILLER_0_337 VPWR VGND VPWR VGND sky130_ef_sc_hd__decap_40_12
XFILLER_56_363 VGND VGND VPWR VPWR sky130_fd_sc_hd__fill_1
XTAP_TAPCELL_ROW_3_164 VGND VPWR sky130_fd_sc_hd__tapvpwrvgnd_1
XTAP_TAPCELL_ROW_54_520 VGND VPWR sky130_fd_sc_hd__tapvpwrvgnd_1
XFILLER_16_249 VGND VGND VPWR VPWR sky130_fd_sc_hd__fill_2
XFILLER_24_271 VGND VGND VPWR VPWR sky130_fd_sc_hd__fill_4
XFILLER_24_282 VGND VGND VPWR VPWR sky130_fd_sc_hd__fill_1
XFILLER_39_319 VGND VGND VPWR VPWR sky130_fd_sc_hd__fill_2
Xhold4 hold4/A VGND VGND VPWR VPWR hold4/X sky130_fd_sc_hd__dlygate4sd3_1
XFILLER_62_333 VPWR VGND VPWR VGND sky130_ef_sc_hd__decap_40_12
XFILLER_47_385 VGND VGND VPWR VPWR sky130_fd_sc_hd__fill_4
XFILLER_62_377 VPWR VGND VPWR VGND sky130_ef_sc_hd__decap_40_12
XFILLER_30_296 VGND VGND VPWR VPWR sky130_fd_sc_hd__fill_4
XFILLER_15_293 VPWR VGND VPWR VGND sky130_ef_sc_hd__decap_40_12
XFILLER_57_149 VPWR VGND VPWR VGND sky130_ef_sc_hd__decap_40_12
XFILLER_57_105 VGND VGND VPWR VPWR sky130_fd_sc_hd__fill_4
XFILLER_54_29 VPWR VGND VPWR VGND sky130_ef_sc_hd__decap_40_12
XFILLER_53_333 VGND VGND VPWR VPWR sky130_fd_sc_hd__fill_2
XTAP_TAPCELL_ROW_0_134 VGND VPWR sky130_fd_sc_hd__tapvpwrvgnd_1
XPHY_EDGE_ROW_17_Right_17 VGND VGND VPWR VPWR sky130_fd_sc_hd__decap_3
XPHY_EDGE_ROW_26_Right_26 VGND VGND VPWR VPWR sky130_fd_sc_hd__decap_3
XFILLER_0_167 VGND VGND VPWR VPWR sky130_fd_sc_hd__fill_1
XFILLER_56_193 VGND VGND VPWR VPWR sky130_fd_sc_hd__fill_2
XFILLER_44_333 VPWR VGND VPWR VGND sky130_ef_sc_hd__decap_40_12
XFILLER_28_85 VPWR VGND VPWR VGND sky130_ef_sc_hd__decap_40_12
XFILLER_28_41 VPWR VGND VPWR VGND sky130_ef_sc_hd__decap_40_12
X_563_ _564_/CLK _563_/D VGND VGND VPWR VPWR _563_/Q sky130_fd_sc_hd__dfxtp_1
XFILLER_0_189 VGND VGND VPWR VPWR sky130_fd_sc_hd__fill_2
XFILLER_44_377 VPWR VGND VPWR VGND sky130_ef_sc_hd__decap_40_12
XPHY_EDGE_ROW_35_Right_35 VGND VGND VPWR VPWR sky130_fd_sc_hd__decap_3
X_494_ _516_/CLK hold6/X VGND VGND VPWR VPWR hold5/A sky130_fd_sc_hd__dfxtp_1
XFILLER_8_245 VGND VGND VPWR VPWR sky130_fd_sc_hd__fill_4
XTAP_TAPCELL_ROW_14_236 VGND VPWR sky130_fd_sc_hd__tapvpwrvgnd_1
XFILLER_60_83 VGND VGND VPWR VPWR sky130_fd_sc_hd__fill_1
XFILLER_8_289 VPWR VGND VPWR VGND sky130_ef_sc_hd__decap_40_12
XTAP_TAPCELL_ROW_22_291 VGND VPWR sky130_fd_sc_hd__tapvpwrvgnd_1
XPHY_EDGE_ROW_44_Right_44 VGND VGND VPWR VPWR sky130_fd_sc_hd__decap_3
XFILLER_39_149 VPWR VGND VPWR VGND sky130_ef_sc_hd__decap_40_12
XFILLER_39_105 VGND VGND VPWR VPWR sky130_fd_sc_hd__fill_4
XFILLER_62_141 VPWR VGND VPWR VGND sky130_ef_sc_hd__decap_40_12
XPHY_EDGE_ROW_53_Right_53 VGND VGND VPWR VPWR sky130_fd_sc_hd__decap_3
XFILLER_47_193 VPWR VGND VPWR VGND sky130_ef_sc_hd__decap_40_12
XPHY_EDGE_ROW_62_Right_62 VGND VGND VPWR VPWR sky130_fd_sc_hd__decap_3
XPHY_EDGE_ROW_37_Left_102 VGND VGND VPWR VPWR sky130_fd_sc_hd__decap_3
XTAP_TAPCELL_ROW_28_339 VGND VPWR sky130_fd_sc_hd__tapvpwrvgnd_1
XFILLER_26_333 VPWR VGND VPWR VGND sky130_ef_sc_hd__decap_40_12
XPHY_EDGE_ROW_46_Left_111 VGND VGND VPWR VPWR sky130_fd_sc_hd__decap_3
XTAP_TAPCELL_ROW_36_394 VGND VPWR sky130_fd_sc_hd__tapvpwrvgnd_1
XTAP_TAPCELL_ROW_11_217 VGND VPWR sky130_fd_sc_hd__tapvpwrvgnd_1
XFILLER_14_65 VPWR VGND VPWR VGND sky130_ef_sc_hd__decap_40_12
XPHY_EDGE_ROW_55_Left_120 VGND VGND VPWR VPWR sky130_fd_sc_hd__decap_3
XFILLER_30_97 VPWR VGND VPWR VGND sky130_ef_sc_hd__decap_40_12
XFILLER_30_53 VPWR VGND VPWR VGND sky130_ef_sc_hd__decap_40_12
XFILLER_5_237 VPWR VGND VPWR VGND sky130_ef_sc_hd__decap_40_12
XFILLER_39_51 VGND VGND VPWR VPWR sky130_fd_sc_hd__fill_4
XFILLER_44_141 VPWR VGND VPWR VGND sky130_ef_sc_hd__decap_40_12
X_546_ _564_/CLK _546_/D VGND VGND VPWR VPWR _546_/Q sky130_fd_sc_hd__dfxtp_1
XFILLER_17_311 VGND VGND VPWR VPWR sky130_fd_sc_hd__fill_4
X_477_ _480_/B _480_/C _481_/A VGND VGND VPWR VPWR _477_/Y sky130_fd_sc_hd__o21ai_1
XFILLER_50_177 VPWR VGND VPWR VGND sky130_ef_sc_hd__decap_40_12
XFILLER_50_133 VGND VGND VPWR VPWR sky130_fd_sc_hd__fill_4
XFILLER_35_174 VGND VGND VPWR VPWR sky130_fd_sc_hd__fill_2
XFILLER_58_233 VPWR VGND VPWR VGND sky130_ef_sc_hd__decap_40_12
XFILLER_58_277 VPWR VGND VPWR VGND sky130_ef_sc_hd__decap_40_12
XFILLER_41_111 VGND VGND VPWR VPWR sky130_fd_sc_hd__fill_1
X_331_ hold52/X _337_/C _330_/X _273_/A VGND VGND VPWR VPWR _331_/X sky130_fd_sc_hd__o211a_1
X_400_ _403_/B _403_/C _403_/D VGND VGND VPWR VPWR _402_/A sky130_fd_sc_hd__and3_1
XFILLER_26_185 VGND VGND VPWR VPWR sky130_fd_sc_hd__fill_2
XFILLER_26_141 VPWR VGND VPWR VGND sky130_ef_sc_hd__decap_40_12
X_262_ _533_/Q _532_/Q _530_/Q _531_/Q VGND VGND VPWR VPWR _265_/C sky130_fd_sc_hd__or4b_1
XANTENNA_fanout13_X _337_/B VGND VGND VPWR VPWR sky130_fd_sc_hd__diode_2
XFILLER_64_225 VPWR VGND VPWR VGND sky130_ef_sc_hd__decap_40_12
XFILLER_49_277 VGND VGND VPWR VPWR sky130_fd_sc_hd__fill_2
XFILLER_1_273 VGND VGND VPWR VPWR sky130_fd_sc_hd__fill_4
XTAP_TAPCELL_ROW_47_467 VGND VPWR sky130_fd_sc_hd__tapvpwrvgnd_1
XFILLER_32_133 VGND VGND VPWR VPWR sky130_fd_sc_hd__fill_4
X_529_ _561_/CLK _529_/D VGND VGND VPWR VPWR _529_/Q sky130_fd_sc_hd__dfxtp_1
XFILLER_9_373 VPWR VGND VPWR VGND sky130_ef_sc_hd__decap_40_12
XFILLER_13_391 VGND VGND VPWR VPWR sky130_fd_sc_hd__fill_1
XFILLER_55_225 VPWR VGND VPWR VGND sky130_ef_sc_hd__decap_40_12
XFILLER_23_111 VGND VGND VPWR VPWR sky130_fd_sc_hd__fill_1
XFILLER_62_29 VPWR VGND VPWR VGND sky130_ef_sc_hd__decap_40_12
XFILLER_11_317 VPWR VGND VPWR VGND sky130_ef_sc_hd__decap_40_12
XFILLER_11_55 VGND VGND VPWR VPWR sky130_fd_sc_hd__fill_1
XFILLER_19_406 VGND VGND VPWR VPWR sky130_fd_sc_hd__fill_1
XFILLER_61_217 VGND VGND VPWR VPWR sky130_fd_sc_hd__fill_4
XTAP_TAPCELL_ROW_44_448 VGND VPWR sky130_fd_sc_hd__tapvpwrvgnd_1
XFILLER_36_85 VPWR VGND VPWR VGND sky130_ef_sc_hd__decap_40_12
XFILLER_36_41 VPWR VGND VPWR VGND sky130_ef_sc_hd__decap_40_12
X_314_ _512_/Q _306_/B _485_/A VGND VGND VPWR VPWR _314_/X sky130_fd_sc_hd__a21o_1
XFILLER_14_133 VGND VGND VPWR VPWR sky130_fd_sc_hd__fill_4
XFILLER_14_177 VPWR VGND VPWR VGND sky130_ef_sc_hd__decap_40_12
X_245_ _505_/Q VGND VGND VPWR VPWR _245_/Y sky130_fd_sc_hd__inv_2
XFILLER_6_321 VPWR VGND VPWR VGND sky130_ef_sc_hd__decap_40_12
XFILLER_6_365 VPWR VGND VPWR VGND sky130_ef_sc_hd__decap_40_12
XFILLER_10_361 VGND VGND VPWR VPWR sky130_fd_sc_hd__fill_2
XFILLER_37_225 VGND VGND VPWR VPWR sky130_fd_sc_hd__fill_2
XFILLER_9_181 VPWR VGND VPWR VGND sky130_ef_sc_hd__decap_40_12
XFILLER_51_261 VPWR VGND VPWR VGND sky130_ef_sc_hd__decap_40_12
XFILLER_43_239 VPWR VGND VPWR VGND sky130_ef_sc_hd__decap_40_12
XTAP_TAPCELL_ROW_41_429 VGND VPWR sky130_fd_sc_hd__tapvpwrvgnd_1
XFILLER_11_125 VPWR VGND VPWR VGND sky130_ef_sc_hd__decap_40_12
XFILLER_11_169 VPWR VGND VPWR VGND sky130_ef_sc_hd__decap_40_12
XFILLER_22_65 VPWR VGND VPWR VGND sky130_ef_sc_hd__decap_40_12
XFILLER_3_335 VGND VGND VPWR VPWR sky130_fd_sc_hd__fill_1
XFILLER_0_3 VPWR VGND VPWR VGND sky130_ef_sc_hd__decap_40_12
XFILLER_59_361 VPWR VGND VPWR VGND sky130_ef_sc_hd__decap_40_12
XTAP_TAPCELL_ROW_57_540 VGND VPWR sky130_fd_sc_hd__tapvpwrvgnd_1
XFILLER_47_51 VGND VGND VPWR VPWR sky130_fd_sc_hd__fill_4
XTAP_TAPCELL_ROW_6_184 VGND VPWR sky130_fd_sc_hd__tapvpwrvgnd_1
XFILLER_19_225 VPWR VGND VPWR VGND sky130_ef_sc_hd__decap_40_12
XFILLER_27_291 VGND VGND VPWR VPWR sky130_fd_sc_hd__fill_1
XFILLER_6_195 VGND VGND VPWR VPWR sky130_fd_sc_hd__fill_1
XFILLER_33_3 VPWR VGND VPWR VGND sky130_ef_sc_hd__decap_40_12
XFILLER_25_206 VPWR VGND VPWR VGND sky130_ef_sc_hd__decap_40_12
XFILLER_18_280 VGND VGND VPWR VPWR sky130_fd_sc_hd__fill_2
XFILLER_0_349 VPWR VGND VPWR VGND sky130_ef_sc_hd__decap_40_12
XFILLER_0_305 VGND VGND VPWR VPWR sky130_fd_sc_hd__fill_2
XTAP_TAPCELL_ROW_54_521 VGND VPWR sky130_fd_sc_hd__tapvpwrvgnd_1
XFILLER_48_309 VPWR VGND VPWR VGND sky130_ef_sc_hd__decap_40_12
XFILLER_8_405 VGND VGND VPWR VPWR sky130_fd_sc_hd__fill_2
XFILLER_12_401 VGND VGND VPWR VPWR sky130_fd_sc_hd__fill_4
XFILLER_58_83 VGND VGND VPWR VPWR sky130_fd_sc_hd__fill_1
Xhold5 hold5/A VGND VGND VPWR VPWR hold5/X sky130_fd_sc_hd__dlygate4sd3_1
XFILLER_3_165 VGND VGND VPWR VPWR sky130_fd_sc_hd__fill_2
XFILLER_62_389 VPWR VGND VPWR VGND sky130_ef_sc_hd__decap_40_12
XFILLER_62_345 VPWR VGND VPWR VGND sky130_ef_sc_hd__decap_40_12
XFILLER_62_301 VGND VGND VPWR VPWR sky130_fd_sc_hd__fill_4
XFILLER_15_261 VPWR VGND VPWR VGND sky130_ef_sc_hd__decap_40_12
XTAP_TAPCELL_ROW_17_256 VGND VPWR sky130_fd_sc_hd__tapvpwrvgnd_1
XFILLER_22_209 VPWR VGND VPWR VGND sky130_ef_sc_hd__decap_40_12
XTAP_TAPCELL_ROW_60_557 VGND VPWR sky130_fd_sc_hd__tapvpwrvgnd_1
XFILLER_30_242 VGND VGND VPWR VPWR sky130_fd_sc_hd__fill_8
XPHY_EDGE_ROW_29_Left_94 VGND VGND VPWR VPWR sky130_fd_sc_hd__decap_3
XTAP_TAPCELL_ROW_0_135 VGND VPWR sky130_fd_sc_hd__tapvpwrvgnd_1
XPHY_EDGE_ROW_13_Left_78 VGND VGND VPWR VPWR sky130_fd_sc_hd__decap_3
XFILLER_53_389 VGND VGND VPWR VPWR sky130_fd_sc_hd__fill_2
XFILLER_21_297 VGND VGND VPWR VPWR sky130_fd_sc_hd__fill_2
XFILLER_48_139 VGND VGND VPWR VPWR sky130_fd_sc_hd__fill_1
XFILLER_0_113 VPWR VGND VPWR VGND sky130_ef_sc_hd__decap_40_12
XFILLER_63_109 VGND VGND VPWR VPWR sky130_fd_sc_hd__fill_2
XFILLER_44_389 VPWR VGND VPWR VGND sky130_ef_sc_hd__decap_40_12
XFILLER_44_345 VPWR VGND VPWR VGND sky130_ef_sc_hd__decap_40_12
XFILLER_44_41 VPWR VGND VPWR VGND sky130_ef_sc_hd__decap_40_12
X_493_ _516_/CLK _493_/D VGND VGND VPWR VPWR _493_/Q sky130_fd_sc_hd__dfxtp_1
X_562_ _564_/CLK _562_/D VGND VGND VPWR VPWR _562_/Q sky130_fd_sc_hd__dfxtp_1
XFILLER_28_97 VPWR VGND VPWR VGND sky130_ef_sc_hd__decap_40_12
XFILLER_28_53 VPWR VGND VPWR VGND sky130_ef_sc_hd__decap_40_12
XFILLER_44_85 VPWR VGND VPWR VGND sky130_ef_sc_hd__decap_40_12
XFILLER_12_253 VPWR VGND VPWR VGND sky130_ef_sc_hd__decap_40_12
XTAP_TAPCELL_ROW_14_237 VGND VPWR sky130_fd_sc_hd__tapvpwrvgnd_1
XTAP_TAPCELL_ROW_22_292 VGND VPWR sky130_fd_sc_hd__tapvpwrvgnd_1
XFILLER_5_57 VPWR VGND VPWR VGND sky130_ef_sc_hd__decap_40_12
XFILLER_54_109 VPWR VGND VPWR VGND sky130_ef_sc_hd__decap_40_12
XFILLER_47_161 VGND VGND VPWR VPWR sky130_fd_sc_hd__fill_4
XFILLER_62_197 VPWR VGND VPWR VGND sky130_ef_sc_hd__decap_40_12
XFILLER_62_153 VPWR VGND VPWR VGND sky130_ef_sc_hd__decap_40_12
XFILLER_45_109 VGND VGND VPWR VPWR sky130_fd_sc_hd__fill_2
XFILLER_26_345 VGND VGND VPWR VPWR sky130_fd_sc_hd__fill_2
XFILLER_41_337 VGND VGND VPWR VPWR sky130_fd_sc_hd__fill_4
XTAP_TAPCELL_ROW_36_395 VGND VPWR sky130_fd_sc_hd__tapvpwrvgnd_1
XTAP_TAPCELL_ROW_11_218 VGND VPWR sky130_fd_sc_hd__tapvpwrvgnd_1
XFILLER_14_77 VGND VGND VPWR VPWR sky130_fd_sc_hd__fill_4
XFILLER_30_65 VPWR VGND VPWR VGND sky130_ef_sc_hd__decap_40_12
XFILLER_5_249 VPWR VGND VPWR VGND sky130_ef_sc_hd__decap_40_12
XFILLER_5_205 VPWR VGND VPWR VGND sky130_ef_sc_hd__decap_40_12
XFILLER_36_109 VPWR VGND VPWR VGND sky130_ef_sc_hd__decap_40_12
XFILLER_29_161 VGND VGND VPWR VPWR sky130_fd_sc_hd__fill_4
XFILLER_55_51 VGND VGND VPWR VPWR sky130_fd_sc_hd__fill_4
XFILLER_44_197 VPWR VGND VPWR VGND sky130_ef_sc_hd__decap_40_12
XFILLER_44_153 VPWR VGND VPWR VGND sky130_ef_sc_hd__decap_40_12
X_545_ _545_/CLK _545_/D VGND VGND VPWR VPWR hold1/A sky130_fd_sc_hd__dfxtp_1
X_476_ _480_/C _476_/B VGND VGND VPWR VPWR _476_/Y sky130_fd_sc_hd__nor2_1
XFILLER_17_323 VPWR VGND VPWR VGND sky130_ef_sc_hd__decap_40_12
XFILLER_17_389 VGND VGND VPWR VPWR sky130_fd_sc_hd__fill_2
XFILLER_27_109 VGND VGND VPWR VPWR sky130_fd_sc_hd__fill_2
XFILLER_50_189 VGND VGND VPWR VPWR sky130_fd_sc_hd__fill_4
XFILLER_58_289 VPWR VGND VPWR VGND sky130_ef_sc_hd__decap_40_12
XFILLER_58_245 VGND VGND VPWR VPWR sky130_fd_sc_hd__fill_4
XPHY_EDGE_ROW_16_Left_81 VGND VGND VPWR VPWR sky130_fd_sc_hd__decap_3
XFILLER_18_109 VPWR VGND VPWR VGND sky130_ef_sc_hd__decap_40_12
X_330_ _333_/A _330_/B VGND VGND VPWR VPWR _330_/X sky130_fd_sc_hd__or2_1
XFILLER_26_197 VGND VGND VPWR VPWR sky130_fd_sc_hd__fill_2
XFILLER_26_153 VPWR VGND VPWR VGND sky130_ef_sc_hd__decap_40_12
XTAP_TAPCELL_ROW_24_310 VGND VPWR sky130_fd_sc_hd__tapvpwrvgnd_1
XFILLER_41_167 VGND VGND VPWR VPWR sky130_fd_sc_hd__fill_1
X_261_ _539_/Q _538_/Q _256_/B _528_/Q VGND VGND VPWR VPWR _265_/B sky130_fd_sc_hd__or4bb_1
XFILLER_49_223 VGND VGND VPWR VPWR sky130_fd_sc_hd__fill_1
XFILLER_64_237 VPWR VGND VPWR VGND sky130_ef_sc_hd__decap_40_12
XTAP_TAPCELL_ROW_47_468 VGND VPWR sky130_fd_sc_hd__tapvpwrvgnd_1
X_528_ _545_/CLK _528_/D VGND VGND VPWR VPWR _528_/Q sky130_fd_sc_hd__dfxtp_1
XFILLER_20_307 VGND VGND VPWR VPWR sky130_fd_sc_hd__fill_1
X_459_ _466_/D _481_/A _459_/C VGND VGND VPWR VPWR _459_/X sky130_fd_sc_hd__and3b_1
XFILLER_63_3 VPWR VGND VPWR VGND sky130_ef_sc_hd__decap_40_12
XFILLER_9_385 VGND VGND VPWR VPWR sky130_fd_sc_hd__fill_4
XFILLER_63_281 VPWR VGND VPWR VGND sky130_ef_sc_hd__decap_40_12
XFILLER_55_237 VPWR VGND VPWR VGND sky130_ef_sc_hd__decap_40_12
XFILLER_11_329 VGND VGND VPWR VPWR sky130_fd_sc_hd__fill_4
XFILLER_23_167 VGND VGND VPWR VPWR sky130_fd_sc_hd__fill_1
XFILLER_36_53 VPWR VGND VPWR VGND sky130_ef_sc_hd__decap_40_12
XFILLER_52_85 VPWR VGND VPWR VGND sky130_ef_sc_hd__decap_40_12
XFILLER_52_41 VPWR VGND VPWR VGND sky130_ef_sc_hd__decap_40_12
XTAP_TAPCELL_ROW_44_449 VGND VPWR sky130_fd_sc_hd__tapvpwrvgnd_1
X_313_ hold9/X _283_/X _312_/X VGND VGND VPWR VPWR _313_/X sky130_fd_sc_hd__a21o_1
X_244_ _390_/B VGND VGND VPWR VPWR _374_/A sky130_fd_sc_hd__inv_2
XFILLER_36_97 VPWR VGND VPWR VGND sky130_ef_sc_hd__decap_40_12
XPHY_EDGE_ROW_1_Left_66 VGND VGND VPWR VPWR sky130_fd_sc_hd__decap_3
XFILLER_14_189 VGND VGND VPWR VPWR sky130_fd_sc_hd__fill_4
XFILLER_6_333 VPWR VGND VPWR VGND sky130_ef_sc_hd__decap_40_12
XFILLER_6_377 VPWR VGND VPWR VGND sky130_ef_sc_hd__decap_40_12
XFILLER_60_251 VGND VGND VPWR VPWR sky130_fd_sc_hd__fill_1
XFILLER_9_193 VPWR VGND VPWR VGND sky130_ef_sc_hd__decap_40_12
XFILLER_20_137 VGND VGND VPWR VPWR sky130_fd_sc_hd__fill_2
XFILLER_28_248 VGND VGND VPWR VPWR sky130_fd_sc_hd__fill_2
XFILLER_51_273 VGND VGND VPWR VPWR sky130_fd_sc_hd__fill_4
XFILLER_11_137 VPWR VGND VPWR VGND sky130_ef_sc_hd__decap_40_12
XFILLER_22_77 VGND VGND VPWR VPWR sky130_fd_sc_hd__fill_4
XFILLER_59_373 VPWR VGND VPWR VGND sky130_ef_sc_hd__decap_40_12
XTAP_TAPCELL_ROW_6_185 VGND VPWR sky130_fd_sc_hd__tapvpwrvgnd_1
XFILLER_63_51 VGND VGND VPWR VPWR sky130_fd_sc_hd__fill_4
XTAP_TAPCELL_ROW_57_541 VGND VPWR sky130_fd_sc_hd__tapvpwrvgnd_1
XFILLER_19_237 VGND VGND VPWR VPWR sky130_fd_sc_hd__fill_4
XFILLER_6_141 VPWR VGND VPWR VGND sky130_ef_sc_hd__decap_40_12
XFILLER_26_3 VPWR VGND VPWR VGND sky130_ef_sc_hd__decap_40_12
XFILLER_25_218 VGND VGND VPWR VPWR sky130_fd_sc_hd__fill_4
XFILLER_56_365 VPWR VGND VPWR VGND sky130_ef_sc_hd__decap_40_12
XFILLER_56_321 VPWR VGND VPWR VGND sky130_ef_sc_hd__decap_40_12
XFILLER_17_55 VGND VGND VPWR VPWR sky130_fd_sc_hd__fill_1
XFILLER_3_111 VGND VGND VPWR VPWR sky130_fd_sc_hd__fill_1
XFILLER_59_181 VPWR VGND VPWR VGND sky130_ef_sc_hd__decap_40_12
Xhold6 hold6/A VGND VGND VPWR VPWR hold6/X sky130_fd_sc_hd__dlygate4sd3_1
XFILLER_62_357 VGND VGND VPWR VPWR sky130_fd_sc_hd__fill_4
XFILLER_15_273 VGND VGND VPWR VPWR sky130_fd_sc_hd__fill_4
XTAP_TAPCELL_ROW_17_257 VGND VPWR sky130_fd_sc_hd__tapvpwrvgnd_1
XTAP_TAPCELL_ROW_60_558 VGND VPWR sky130_fd_sc_hd__tapvpwrvgnd_1
XFILLER_53_335 VGND VGND VPWR VPWR sky130_fd_sc_hd__fill_1
XTAP_TAPCELL_ROW_0_136 VGND VPWR sky130_fd_sc_hd__tapvpwrvgnd_1
XPHY_EDGE_ROW_3_Right_3 VGND VGND VPWR VPWR sky130_fd_sc_hd__decap_3
XFILLER_21_221 VGND VGND VPWR VPWR sky130_fd_sc_hd__fill_2
XFILLER_28_65 VPWR VGND VPWR VGND sky130_ef_sc_hd__decap_40_12
XFILLER_0_125 VPWR VGND VPWR VGND sky130_ef_sc_hd__decap_40_12
XFILLER_0_169 VPWR VGND VPWR VGND sky130_ef_sc_hd__decap_40_12
XFILLER_56_195 VGND VGND VPWR VPWR sky130_fd_sc_hd__fill_1
XFILLER_44_357 VGND VGND VPWR VPWR sky130_fd_sc_hd__fill_4
XFILLER_44_302 VGND VGND VPWR VPWR sky130_fd_sc_hd__fill_4
XFILLER_44_53 VPWR VGND VPWR VGND sky130_ef_sc_hd__decap_40_12
X_492_ _516_/CLK _492_/D VGND VGND VPWR VPWR _492_/Q sky130_fd_sc_hd__dfxtp_1
X_561_ _561_/CLK _561_/D VGND VGND VPWR VPWR _561_/Q sky130_fd_sc_hd__dfxtp_1
XFILLER_12_221 VPWR VGND VPWR VGND sky130_ef_sc_hd__decap_40_12
XFILLER_60_85 VPWR VGND VPWR VGND sky130_ef_sc_hd__decap_40_12
XFILLER_60_41 VPWR VGND VPWR VGND sky130_ef_sc_hd__decap_40_12
XFILLER_44_97 VPWR VGND VPWR VGND sky130_ef_sc_hd__decap_40_12
XPHY_EDGE_ROW_30_Left_95 VGND VGND VPWR VPWR sky130_fd_sc_hd__decap_3
XFILLER_12_265 VPWR VGND VPWR VGND sky130_ef_sc_hd__decap_40_12
XTAP_TAPCELL_ROW_14_238 VGND VPWR sky130_fd_sc_hd__tapvpwrvgnd_1
XTAP_TAPCELL_ROW_22_293 VGND VPWR sky130_fd_sc_hd__tapvpwrvgnd_1
XFILLER_5_69 VPWR VGND VPWR VGND sky130_ef_sc_hd__decap_40_12
XFILLER_62_121 VPWR VGND VPWR VGND sky130_ef_sc_hd__decap_40_12
XFILLER_35_335 VGND VGND VPWR VPWR sky130_fd_sc_hd__fill_1
XFILLER_35_302 VGND VGND VPWR VPWR sky130_fd_sc_hd__fill_4
XFILLER_62_165 VPWR VGND VPWR VGND sky130_ef_sc_hd__decap_40_12
XFILLER_50_305 VGND VGND VPWR VPWR sky130_fd_sc_hd__fill_2
XFILLER_58_405 VGND VGND VPWR VPWR sky130_fd_sc_hd__fill_2
XFILLER_53_165 VGND VGND VPWR VPWR sky130_fd_sc_hd__fill_2
XFILLER_5_217 VGND VGND VPWR VPWR sky130_fd_sc_hd__fill_4
XTAP_TAPCELL_ROW_11_219 VGND VPWR sky130_fd_sc_hd__tapvpwrvgnd_1
XFILLER_49_405 VGND VGND VPWR VPWR sky130_fd_sc_hd__fill_2
XFILLER_30_77 VGND VGND VPWR VPWR sky130_fd_sc_hd__fill_4
XFILLER_44_121 VPWR VGND VPWR VGND sky130_ef_sc_hd__decap_40_12
XFILLER_17_335 VGND VGND VPWR VPWR sky130_fd_sc_hd__fill_1
XFILLER_44_165 VPWR VGND VPWR VGND sky130_ef_sc_hd__decap_40_12
X_544_ _544_/CLK _544_/D VGND VGND VPWR VPWR _544_/Q sky130_fd_sc_hd__dfxtp_4
XTAP_TAPCELL_ROW_27_330 VGND VPWR sky130_fd_sc_hd__tapvpwrvgnd_1
X_475_ _474_/A _472_/X _481_/A VGND VGND VPWR VPWR _475_/Y sky130_fd_sc_hd__o21ai_1
XFILLER_35_176 VGND VGND VPWR VPWR sky130_fd_sc_hd__fill_1
XFILLER_2_209 VPWR VGND VPWR VGND sky130_ef_sc_hd__decap_40_12
XFILLER_26_121 VPWR VGND VPWR VGND sky130_ef_sc_hd__decap_40_12
XFILLER_41_113 VPWR VGND VPWR VGND sky130_ef_sc_hd__decap_40_12
X_260_ _260_/A _260_/B _260_/C _260_/D VGND VGND VPWR VPWR _260_/X sky130_fd_sc_hd__or4_2
XFILLER_26_187 VGND VGND VPWR VPWR sky130_fd_sc_hd__fill_1
XFILLER_26_165 VPWR VGND VPWR VGND sky130_ef_sc_hd__decap_40_12
XFILLER_25_55 VGND VGND VPWR VPWR sky130_fd_sc_hd__fill_1
XTAP_TAPCELL_ROW_24_311 VGND VPWR sky130_fd_sc_hd__tapvpwrvgnd_1
XFILLER_14_305 VGND VGND VPWR VPWR sky130_fd_sc_hd__fill_2
XFILLER_22_360 VGND VGND VPWR VPWR sky130_fd_sc_hd__fill_4
XFILLER_2_15 VPWR VGND VPWR VGND sky130_ef_sc_hd__decap_40_12
XFILLER_64_249 VGND VGND VPWR VPWR sky130_fd_sc_hd__fill_2
XFILLER_49_279 VGND VGND VPWR VPWR sky130_fd_sc_hd__fill_1
XTAP_TAPCELL_ROW_47_469 VGND VPWR sky130_fd_sc_hd__tapvpwrvgnd_1
X_527_ _544_/CLK _527_/D VGND VGND VPWR VPWR _527_/Q sky130_fd_sc_hd__dfxtp_1
XFILLER_17_165 VGND VGND VPWR VPWR sky130_fd_sc_hd__fill_2
X_389_ _390_/B _390_/C _390_/D _390_/A VGND VGND VPWR VPWR _389_/X sky130_fd_sc_hd__o31a_1
XFILLER_32_168 VGND VGND VPWR VPWR sky130_fd_sc_hd__fill_1
XFILLER_32_157 VGND VGND VPWR VPWR sky130_fd_sc_hd__fill_2
XTAP_TAPCELL_ROW_30_347 VGND VPWR sky130_fd_sc_hd__tapvpwrvgnd_1
XFILLER_13_393 VPWR VGND VPWR VGND sky130_ef_sc_hd__decap_40_12
X_458_ _458_/A _458_/B _458_/C _458_/D VGND VGND VPWR VPWR _466_/D sky130_fd_sc_hd__and4_1
XFILLER_56_3 VPWR VGND VPWR VGND sky130_ef_sc_hd__decap_40_12
XFILLER_55_249 VPWR VGND VPWR VGND sky130_ef_sc_hd__decap_40_12
XFILLER_55_205 VPWR VGND VPWR VGND sky130_ef_sc_hd__decap_40_12
XTAP_TAPCELL_ROW_38_403 VGND VPWR sky130_fd_sc_hd__tapvpwrvgnd_1
XFILLER_63_293 VPWR VGND VPWR VGND sky130_ef_sc_hd__decap_40_12
XFILLER_23_113 VPWR VGND VPWR VGND sky130_ef_sc_hd__decap_40_12
XFILLER_11_57 VPWR VGND VPWR VGND sky130_ef_sc_hd__decap_40_12
XFILLER_46_249 VGND VGND VPWR VPWR sky130_fd_sc_hd__fill_2
XFILLER_36_65 VPWR VGND VPWR VGND sky130_ef_sc_hd__decap_40_12
XFILLER_52_97 VPWR VGND VPWR VGND sky130_ef_sc_hd__decap_40_12
XFILLER_52_53 VPWR VGND VPWR VGND sky130_ef_sc_hd__decap_40_12
X_312_ _511_/Q _306_/B _485_/A VGND VGND VPWR VPWR _312_/X sky130_fd_sc_hd__a21o_1
X_243_ _277_/A VGND VGND VPWR VPWR _243_/Y sky130_fd_sc_hd__inv_2
XFILLER_6_301 VGND VGND VPWR VPWR sky130_fd_sc_hd__fill_4
XFILLER_6_345 VPWR VGND VPWR VGND sky130_ef_sc_hd__decap_40_12
XFILLER_6_389 VPWR VGND VPWR VGND sky130_ef_sc_hd__decap_40_12
XFILLER_10_363 VGND VGND VPWR VPWR sky130_fd_sc_hd__fill_1
XFILLER_45_271 VGND VGND VPWR VPWR sky130_fd_sc_hd__fill_1
XFILLER_9_161 VGND VGND VPWR VPWR sky130_fd_sc_hd__fill_4
XFILLER_28_205 VGND VGND VPWR VPWR sky130_fd_sc_hd__fill_1
XFILLER_7_109 VGND VGND VPWR VPWR sky130_fd_sc_hd__fill_2
XFILLER_11_105 VGND VGND VPWR VPWR sky130_fd_sc_hd__fill_4
XFILLER_11_149 VPWR VGND VPWR VGND sky130_ef_sc_hd__decap_40_12
XFILLER_3_337 VPWR VGND VPWR VGND sky130_ef_sc_hd__decap_40_12
XFILLER_59_385 VGND VGND VPWR VPWR sky130_fd_sc_hd__fill_4
XFILLER_19_205 VPWR VGND VPWR VGND sky130_ef_sc_hd__decap_40_12
XTAP_TAPCELL_ROW_57_542 VGND VPWR sky130_fd_sc_hd__tapvpwrvgnd_1
XFILLER_34_219 VPWR VGND VPWR VGND sky130_ef_sc_hd__decap_40_12
XTAP_TAPCELL_ROW_40_420 VGND VPWR sky130_fd_sc_hd__tapvpwrvgnd_1
XFILLER_6_153 VPWR VGND VPWR VGND sky130_ef_sc_hd__decap_40_12
XFILLER_10_193 VGND VGND VPWR VPWR sky130_fd_sc_hd__fill_2
XFILLER_6_197 VPWR VGND VPWR VGND sky130_ef_sc_hd__decap_40_12
XFILLER_19_3 VPWR VGND VPWR VGND sky130_ef_sc_hd__decap_40_12
XTAP_TAPCELL_ROW_63_578 VGND VPWR sky130_fd_sc_hd__tapvpwrvgnd_1
XFILLER_0_307 VGND VGND VPWR VPWR sky130_fd_sc_hd__fill_1
XFILLER_56_377 VPWR VGND VPWR VGND sky130_ef_sc_hd__decap_40_12
XFILLER_56_333 VPWR VGND VPWR VGND sky130_ef_sc_hd__decap_40_12
XFILLER_33_55 VGND VGND VPWR VPWR sky130_fd_sc_hd__fill_1
XFILLER_3_167 VGND VGND VPWR VPWR sky130_fd_sc_hd__fill_1
XFILLER_59_193 VPWR VGND VPWR VGND sky130_ef_sc_hd__decap_40_12
XFILLER_58_85 VPWR VGND VPWR VGND sky130_ef_sc_hd__decap_40_12
XFILLER_58_41 VPWR VGND VPWR VGND sky130_ef_sc_hd__decap_40_12
XFILLER_47_333 VGND VGND VPWR VPWR sky130_fd_sc_hd__fill_2
Xhold7 hold7/A VGND VGND VPWR VPWR hold7/X sky130_fd_sc_hd__dlygate4sd3_1
XTAP_TAPCELL_ROW_60_559 VGND VPWR sky130_fd_sc_hd__tapvpwrvgnd_1
XTAP_TAPCELL_ROW_17_258 VGND VPWR sky130_fd_sc_hd__tapvpwrvgnd_1
XFILLER_0_81 VGND VGND VPWR VPWR sky130_fd_sc_hd__fill_2
XTAP_TAPCELL_ROW_0_137 VGND VPWR sky130_fd_sc_hd__tapvpwrvgnd_1
XFILLER_61_391 VGND VGND VPWR VPWR sky130_fd_sc_hd__fill_1
XFILLER_21_233 VGND VGND VPWR VPWR sky130_fd_sc_hd__fill_1
XFILLER_56_141 VPWR VGND VPWR VGND sky130_ef_sc_hd__decap_40_12
XFILLER_28_77 VGND VGND VPWR VPWR sky130_fd_sc_hd__fill_4
XFILLER_0_137 VGND VGND VPWR VPWR sky130_fd_sc_hd__fill_2
X_560_ _561_/CLK _560_/D VGND VGND VPWR VPWR _560_/Q sky130_fd_sc_hd__dfxtp_1
XFILLER_44_65 VPWR VGND VPWR VGND sky130_ef_sc_hd__decap_40_12
X_491_ _565_/CLK _491_/D VGND VGND VPWR VPWR _491_/Q sky130_fd_sc_hd__dfxtp_1
XFILLER_12_233 VPWR VGND VPWR VGND sky130_ef_sc_hd__decap_40_12
XTAP_TAPCELL_ROW_14_239 VGND VPWR sky130_fd_sc_hd__tapvpwrvgnd_1
XFILLER_60_97 VPWR VGND VPWR VGND sky130_ef_sc_hd__decap_40_12
XFILLER_60_53 VPWR VGND VPWR VGND sky130_ef_sc_hd__decap_40_12
XFILLER_5_15 VPWR VGND VPWR VGND sky130_ef_sc_hd__decap_40_12
XFILLER_12_277 VPWR VGND VPWR VGND sky130_ef_sc_hd__decap_40_12
XTAP_TAPCELL_ROW_22_294 VGND VPWR sky130_fd_sc_hd__tapvpwrvgnd_1
XFILLER_62_133 VGND VGND VPWR VPWR sky130_fd_sc_hd__fill_4
XPHY_EDGE_ROW_13_Right_13 VGND VGND VPWR VPWR sky130_fd_sc_hd__decap_3
XFILLER_62_177 VPWR VGND VPWR VGND sky130_ef_sc_hd__decap_40_12
XFILLER_43_391 VGND VGND VPWR VPWR sky130_fd_sc_hd__fill_1
XPHY_EDGE_ROW_22_Right_22 VGND VGND VPWR VPWR sky130_fd_sc_hd__decap_3
XFILLER_7_281 VPWR VGND VPWR VGND sky130_ef_sc_hd__decap_40_12
XFILLER_38_141 VPWR VGND VPWR VGND sky130_ef_sc_hd__decap_40_12
XPHY_EDGE_ROW_31_Right_31 VGND VGND VPWR VPWR sky130_fd_sc_hd__decap_3
XFILLER_53_111 VGND VGND VPWR VPWR sky130_fd_sc_hd__fill_1
XPHY_EDGE_ROW_40_Right_40 VGND VGND VPWR VPWR sky130_fd_sc_hd__decap_3
XFILLER_44_133 VGND VGND VPWR VPWR sky130_fd_sc_hd__fill_4
X_543_ _544_/CLK _543_/D VGND VGND VPWR VPWR _543_/Q sky130_fd_sc_hd__dfxtp_2
XTAP_TAPCELL_ROW_27_331 VGND VPWR sky130_fd_sc_hd__tapvpwrvgnd_1
XFILLER_44_177 VPWR VGND VPWR VGND sky130_ef_sc_hd__decap_40_12
XFILLER_32_317 VGND VGND VPWR VPWR sky130_fd_sc_hd__fill_1
XANTENNA__247__Y _485_/A VGND VGND VPWR VPWR sky130_fd_sc_hd__diode_2
X_474_ _474_/A _560_/Q _474_/C _474_/D VGND VGND VPWR VPWR _480_/C sky130_fd_sc_hd__and4_2
XFILLER_4_251 VGND VGND VPWR VPWR sky130_fd_sc_hd__fill_1
XFILLER_35_111 VGND VGND VPWR VPWR sky130_fd_sc_hd__fill_1
XFILLER_23_317 VGND VGND VPWR VPWR sky130_fd_sc_hd__fill_2
XANTENNA_clkbuf_0_clk_X clkbuf_0_clk/X VGND VGND VPWR VPWR sky130_fd_sc_hd__diode_2
XFILLER_26_133 VGND VGND VPWR VPWR sky130_fd_sc_hd__fill_4
XFILLER_41_169 VGND VGND VPWR VPWR sky130_fd_sc_hd__fill_4
XFILLER_41_125 VPWR VGND VPWR VGND sky130_ef_sc_hd__decap_40_12
XFILLER_26_199 VGND VGND VPWR VPWR sky130_fd_sc_hd__fill_1
XFILLER_26_177 VGND VGND VPWR VPWR sky130_fd_sc_hd__fill_8
XFILLER_41_55 VGND VGND VPWR VPWR sky130_fd_sc_hd__fill_1
XFILLER_49_225 VPWR VGND VPWR VGND sky130_ef_sc_hd__decap_40_12
XFILLER_2_27 VGND VGND VPWR VPWR sky130_fd_sc_hd__fill_1
XFILLER_1_221 VGND VGND VPWR VPWR sky130_fd_sc_hd__fill_2
XFILLER_64_217 VGND VGND VPWR VPWR sky130_fd_sc_hd__fill_4
XFILLER_60_401 VGND VGND VPWR VPWR sky130_fd_sc_hd__fill_4
X_526_ _544_/CLK _526_/D VGND VGND VPWR VPWR _526_/Q sky130_fd_sc_hd__dfxtp_1
XFILLER_17_111 VGND VGND VPWR VPWR sky130_fd_sc_hd__fill_1
X_388_ hold21/X hold50/X _387_/X _337_/B VGND VGND VPWR VPWR _388_/X sky130_fd_sc_hd__o211a_1
XTAP_TAPCELL_ROW_30_348 VGND VPWR sky130_fd_sc_hd__tapvpwrvgnd_1
XFILLER_13_361 VPWR VGND VPWR VGND sky130_ef_sc_hd__decap_40_12
X_457_ _458_/B _458_/C _458_/D _458_/A VGND VGND VPWR VPWR _457_/X sky130_fd_sc_hd__a31o_1
XFILLER_49_3 VPWR VGND VPWR VGND sky130_ef_sc_hd__decap_40_12
XFILLER_55_217 VGND VGND VPWR VPWR sky130_fd_sc_hd__fill_4
XTAP_TAPCELL_ROW_38_404 VGND VPWR sky130_fd_sc_hd__tapvpwrvgnd_1
XFILLER_63_261 VPWR VGND VPWR VGND sky130_ef_sc_hd__decap_40_12
XFILLER_23_125 VPWR VGND VPWR VGND sky130_ef_sc_hd__decap_40_12
XFILLER_23_169 VPWR VGND VPWR VGND sky130_ef_sc_hd__decap_40_12
XFILLER_11_69 VPWR VGND VPWR VGND sky130_ef_sc_hd__decap_40_12
XFILLER_36_77 VGND VGND VPWR VPWR sky130_fd_sc_hd__fill_4
XANTENNA__432__B1 _485_/A VGND VGND VPWR VPWR sky130_fd_sc_hd__diode_2
XFILLER_52_65 VPWR VGND VPWR VGND sky130_ef_sc_hd__decap_40_12
X_311_ hold3/X _283_/X _310_/X VGND VGND VPWR VPWR hold4/A sky130_fd_sc_hd__a21o_1
XFILLER_6_357 VGND VGND VPWR VPWR sky130_fd_sc_hd__fill_4
XANTENNA__429__A _485_/A VGND VGND VPWR VPWR sky130_fd_sc_hd__diode_2
XFILLER_60_253 VPWR VGND VPWR VGND sky130_ef_sc_hd__decap_40_12
XFILLER_52_209 VPWR VGND VPWR VGND sky130_ef_sc_hd__decap_40_12
XFILLER_45_261 VGND VGND VPWR VPWR sky130_fd_sc_hd__fill_8
XTAP_TAPCELL_ROW_43_440 VGND VPWR sky130_fd_sc_hd__tapvpwrvgnd_1
X_509_ _516_/CLK _509_/D VGND VGND VPWR VPWR _509_/Q sky130_fd_sc_hd__dfxtp_1
XFILLER_20_139 VGND VGND VPWR VPWR sky130_fd_sc_hd__fill_1
XFILLER_3_81 VPWR VGND VPWR VGND sky130_ef_sc_hd__decap_40_12
XANTENNA_clkbuf_3_2__f_clk_A clkbuf_0_clk/X VGND VGND VPWR VPWR sky130_fd_sc_hd__diode_2
XFILLER_3_349 VPWR VGND VPWR VGND sky130_ef_sc_hd__decap_40_12
XFILLER_3_305 VPWR VGND VPWR VGND sky130_ef_sc_hd__decap_40_12
XFILLER_19_217 VGND VGND VPWR VPWR sky130_fd_sc_hd__fill_4
XFILLER_8_15 VPWR VGND VPWR VGND sky130_ef_sc_hd__decap_40_12
XTAP_TAPCELL_ROW_40_421 VGND VPWR sky130_fd_sc_hd__tapvpwrvgnd_1
XFILLER_6_121 VPWR VGND VPWR VGND sky130_ef_sc_hd__decap_40_12
XFILLER_6_165 VPWR VGND VPWR VGND sky130_ef_sc_hd__decap_40_12
XTAP_TAPCELL_ROW_63_579 VGND VPWR sky130_fd_sc_hd__tapvpwrvgnd_1
XFILLER_56_345 VPWR VGND VPWR VGND sky130_ef_sc_hd__decap_40_12
XFILLER_56_301 VGND VGND VPWR VPWR sky130_fd_sc_hd__fill_4
XFILLER_56_389 VPWR VGND VPWR VGND sky130_ef_sc_hd__decap_40_12
XFILLER_16_209 VPWR VGND VPWR VGND sky130_ef_sc_hd__decap_40_12
XFILLER_17_57 VPWR VGND VPWR VGND sky130_ef_sc_hd__decap_40_12
XFILLER_24_253 VGND VGND VPWR VPWR sky130_fd_sc_hd__fill_2
XFILLER_58_53 VPWR VGND VPWR VGND sky130_ef_sc_hd__decap_40_12
XFILLER_3_113 VPWR VGND VPWR VGND sky130_ef_sc_hd__decap_40_12
XFILLER_59_161 VGND VGND VPWR VPWR sky130_fd_sc_hd__fill_4
XFILLER_58_97 VPWR VGND VPWR VGND sky130_ef_sc_hd__decap_40_12
XFILLER_47_389 VGND VGND VPWR VPWR sky130_fd_sc_hd__fill_2
Xhold8 hold8/A VGND VGND VPWR VPWR hold8/X sky130_fd_sc_hd__dlygate4sd3_1
XTAP_TAPCELL_ROW_17_259 VGND VPWR sky130_fd_sc_hd__tapvpwrvgnd_1
XFILLER_57_109 VGND VGND VPWR VPWR sky130_fd_sc_hd__fill_2
XFILLER_31_3 VPWR VGND VPWR VGND sky130_ef_sc_hd__decap_40_12
XFILLER_53_337 VPWR VGND VPWR VGND sky130_ef_sc_hd__decap_40_12
XTAP_TAPCELL_ROW_0_138 VGND VPWR sky130_fd_sc_hd__tapvpwrvgnd_1
XFILLER_21_223 VGND VGND VPWR VPWR sky130_fd_sc_hd__fill_1
XFILLER_56_197 VPWR VGND VPWR VGND sky130_ef_sc_hd__decap_40_12
XFILLER_56_153 VPWR VGND VPWR VGND sky130_ef_sc_hd__decap_40_12
XFILLER_48_109 VPWR VGND VPWR VGND sky130_ef_sc_hd__decap_40_12
XFILLER_44_77 VGND VGND VPWR VPWR sky130_fd_sc_hd__fill_4
X_490_ _516_/CLK hold8/X VGND VGND VPWR VPWR hold7/A sky130_fd_sc_hd__dfxtp_1
XFILLER_12_245 VGND VGND VPWR VPWR sky130_fd_sc_hd__fill_4
XFILLER_60_65 VPWR VGND VPWR VGND sky130_ef_sc_hd__decap_40_12
XFILLER_5_27 VPWR VGND VPWR VGND sky130_ef_sc_hd__decap_40_12
XFILLER_8_249 VGND VGND VPWR VPWR sky130_fd_sc_hd__fill_2
XFILLER_12_289 VPWR VGND VPWR VGND sky130_ef_sc_hd__decap_40_12
XTAP_TAPCELL_ROW_22_295 VGND VPWR sky130_fd_sc_hd__tapvpwrvgnd_1
XFILLER_39_109 VGND VGND VPWR VPWR sky130_fd_sc_hd__fill_2
XANTENNA__311__A2 _283_/X VGND VGND VPWR VPWR sky130_fd_sc_hd__diode_2
XFILLER_62_189 VGND VGND VPWR VPWR sky130_fd_sc_hd__fill_4
XFILLER_50_307 VGND VGND VPWR VPWR sky130_fd_sc_hd__fill_1
XFILLER_35_337 VGND VGND VPWR VPWR sky130_fd_sc_hd__fill_1
XFILLER_7_293 VPWR VGND VPWR VGND sky130_ef_sc_hd__decap_40_12
XFILLER_38_197 VGND VGND VPWR VPWR sky130_fd_sc_hd__fill_2
XFILLER_38_153 VGND VGND VPWR VPWR sky130_fd_sc_hd__fill_2
XFILLER_53_167 VGND VGND VPWR VPWR sky130_fd_sc_hd__fill_1
XFILLER_39_55 VGND VGND VPWR VPWR sky130_fd_sc_hd__fill_1
XFILLER_44_189 VGND VGND VPWR VPWR sky130_fd_sc_hd__fill_4
X_542_ _544_/CLK _542_/D VGND VGND VPWR VPWR _542_/Q sky130_fd_sc_hd__dfxtp_2
XTAP_TAPCELL_ROW_27_332 VGND VPWR sky130_fd_sc_hd__tapvpwrvgnd_1
XFILLER_17_304 VGND VGND VPWR VPWR sky130_fd_sc_hd__fill_1
XFILLER_17_337 VPWR VGND VPWR VGND sky130_ef_sc_hd__decap_40_12
X_473_ _472_/X _481_/A _473_/C VGND VGND VPWR VPWR _473_/X sky130_fd_sc_hd__and3b_1
XFILLER_40_384 VGND VGND VPWR VPWR sky130_fd_sc_hd__fill_4
XTAP_TAPCELL_ROW_10_210 VGND VPWR sky130_fd_sc_hd__tapvpwrvgnd_1
XFILLER_50_137 VGND VGND VPWR VPWR sky130_fd_sc_hd__fill_2
XFILLER_35_145 VGND VGND VPWR VPWR sky130_fd_sc_hd__fill_2
XTAP_TAPCELL_ROW_33_368 VGND VPWR sky130_fd_sc_hd__tapvpwrvgnd_1
XFILLER_6_81 VGND VGND VPWR VPWR sky130_fd_sc_hd__fill_2
XFILLER_14_307 VGND VGND VPWR VPWR sky130_fd_sc_hd__fill_1
XFILLER_41_137 VPWR VGND VPWR VGND sky130_ef_sc_hd__decap_40_12
XFILLER_25_57 VPWR VGND VPWR VGND sky130_ef_sc_hd__decap_40_12
XFILLER_9_3 VPWR VGND VPWR VGND sky130_ef_sc_hd__decap_40_12
XFILLER_57_281 VPWR VGND VPWR VGND sky130_ef_sc_hd__decap_40_12
XFILLER_49_237 VPWR VGND VPWR VGND sky130_ef_sc_hd__decap_40_12
XFILLER_1_277 VGND VGND VPWR VPWR sky130_fd_sc_hd__fill_2
X_525_ _544_/CLK _525_/D VGND VGND VPWR VPWR _525_/Q sky130_fd_sc_hd__dfxtp_1
XFILLER_32_159 VGND VGND VPWR VPWR sky130_fd_sc_hd__fill_1
XFILLER_32_137 VGND VGND VPWR VPWR sky130_fd_sc_hd__fill_2
XFILLER_17_167 VGND VGND VPWR VPWR sky130_fd_sc_hd__fill_1
X_456_ _458_/B _455_/B hold99/X _481_/A VGND VGND VPWR VPWR _456_/X sky130_fd_sc_hd__o211a_1
X_387_ _387_/A _387_/B VGND VGND VPWR VPWR _387_/X sky130_fd_sc_hd__or2_1
XTAP_TAPCELL_ROW_30_349 VGND VPWR sky130_fd_sc_hd__tapvpwrvgnd_1
XFILLER_9_333 VGND VGND VPWR VPWR sky130_fd_sc_hd__fill_2
XFILLER_13_373 VPWR VGND VPWR VGND sky130_ef_sc_hd__decap_40_12
XFILLER_63_273 VGND VGND VPWR VPWR sky130_fd_sc_hd__fill_4
XTAP_TAPCELL_ROW_46_460 VGND VPWR sky130_fd_sc_hd__tapvpwrvgnd_1
XPHY_EDGE_ROW_43_Left_108 VGND VGND VPWR VPWR sky130_fd_sc_hd__decap_3
XTAP_TAPCELL_ROW_38_405 VGND VPWR sky130_fd_sc_hd__tapvpwrvgnd_1
XFILLER_23_137 VPWR VGND VPWR VGND sky130_ef_sc_hd__decap_40_12
XPHY_EDGE_ROW_52_Left_117 VGND VGND VPWR VPWR sky130_fd_sc_hd__decap_3
XFILLER_11_15 VPWR VGND VPWR VGND sky130_ef_sc_hd__decap_40_12
XPHY_EDGE_ROW_61_Left_126 VGND VGND VPWR VPWR sky130_fd_sc_hd__decap_3
XFILLER_54_251 VGND VGND VPWR VPWR sky130_fd_sc_hd__fill_1
X_310_ _510_/Q _306_/B _485_/A VGND VGND VPWR VPWR _310_/X sky130_fd_sc_hd__a21o_1
XFILLER_14_137 VGND VGND VPWR VPWR sky130_fd_sc_hd__fill_2
XFILLER_52_77 VGND VGND VPWR VPWR sky130_fd_sc_hd__fill_4
XFILLER_10_321 VPWR VGND VPWR VGND sky130_ef_sc_hd__decap_40_12
XFILLER_10_365 VPWR VGND VPWR VGND sky130_ef_sc_hd__decap_40_12
XFILLER_60_265 VPWR VGND VPWR VGND sky130_ef_sc_hd__decap_40_12
XFILLER_60_221 VPWR VGND VPWR VGND sky130_ef_sc_hd__decap_40_12
XTAP_TAPCELL_ROW_43_441 VGND VPWR sky130_fd_sc_hd__tapvpwrvgnd_1
X_508_ _516_/CLK _508_/D VGND VGND VPWR VPWR _508_/Q sky130_fd_sc_hd__dfxtp_1
XFILLER_13_181 VPWR VGND VPWR VGND sky130_ef_sc_hd__decap_40_12
X_439_ _442_/B _442_/C VGND VGND VPWR VPWR _441_/B sky130_fd_sc_hd__and2_1
XFILLER_61_3 VPWR VGND VPWR VGND sky130_ef_sc_hd__decap_40_12
XFILLER_5_391 VGND VGND VPWR VPWR sky130_fd_sc_hd__fill_1
XFILLER_3_93 VPWR VGND VPWR VGND sky130_ef_sc_hd__decap_40_12
XFILLER_51_221 VGND VGND VPWR VPWR sky130_fd_sc_hd__fill_2
XFILLER_36_251 VGND VGND VPWR VPWR sky130_fd_sc_hd__fill_1
XANTENNA__350__B1 _337_/B VGND VGND VPWR VPWR sky130_fd_sc_hd__diode_2
XFILLER_3_317 VPWR VGND VPWR VGND sky130_ef_sc_hd__decap_40_12
XFILLER_47_55 VGND VGND VPWR VPWR sky130_fd_sc_hd__fill_1
XTAP_TAPCELL_ROW_40_422 VGND VPWR sky130_fd_sc_hd__tapvpwrvgnd_1
XFILLER_8_27 VGND VGND VPWR VPWR sky130_fd_sc_hd__fill_1
XFILLER_6_133 VGND VGND VPWR VPWR sky130_fd_sc_hd__fill_4
XFILLER_6_177 VPWR VGND VPWR VGND sky130_ef_sc_hd__decap_40_12
XFILLER_10_195 VGND VGND VPWR VPWR sky130_fd_sc_hd__fill_1
XFILLER_2_361 VGND VGND VPWR VPWR sky130_fd_sc_hd__fill_2
XFILLER_18_251 VGND VGND VPWR VPWR sky130_fd_sc_hd__fill_1
XFILLER_33_298 VGND VGND VPWR VPWR sky130_fd_sc_hd__fill_2
XFILLER_0_309 VPWR VGND VPWR VGND sky130_ef_sc_hd__decap_40_12
XFILLER_56_357 VGND VGND VPWR VPWR sky130_fd_sc_hd__fill_4
XTAP_TAPCELL_ROW_3_158 VGND VPWR sky130_fd_sc_hd__tapvpwrvgnd_1
XFILLER_33_57 VPWR VGND VPWR VGND sky130_ef_sc_hd__decap_40_12
XFILLER_12_405 VGND VGND VPWR VPWR sky130_fd_sc_hd__fill_2
XFILLER_17_69 VPWR VGND VPWR VGND sky130_ef_sc_hd__decap_40_12
XFILLER_24_221 VGND VGND VPWR VPWR sky130_fd_sc_hd__fill_8
XFILLER_3_125 VPWR VGND VPWR VGND sky130_ef_sc_hd__decap_40_12
XFILLER_58_65 VPWR VGND VPWR VGND sky130_ef_sc_hd__decap_40_12
Xhold9 hold9/A VGND VGND VPWR VPWR hold9/X sky130_fd_sc_hd__dlygate4sd3_1
XFILLER_3_169 VPWR VGND VPWR VGND sky130_ef_sc_hd__decap_40_12
XFILLER_62_305 VGND VGND VPWR VPWR sky130_fd_sc_hd__fill_2
XFILLER_47_335 VGND VGND VPWR VPWR sky130_fd_sc_hd__fill_1
XFILLER_15_221 VGND VGND VPWR VPWR sky130_fd_sc_hd__fill_2
XANTENNA__314__B1 _485_/A VGND VGND VPWR VPWR sky130_fd_sc_hd__diode_2
XFILLER_53_305 VPWR VGND VPWR VGND sky130_ef_sc_hd__decap_40_12
XFILLER_38_313 VGND VGND VPWR VPWR sky130_fd_sc_hd__fill_1
XFILLER_24_3 VPWR VGND VPWR VGND sky130_ef_sc_hd__decap_40_12
XFILLER_61_393 VPWR VGND VPWR VGND sky130_ef_sc_hd__decap_40_12
XFILLER_53_349 VPWR VGND VPWR VGND sky130_ef_sc_hd__decap_40_12
XFILLER_0_83 VGND VGND VPWR VPWR sky130_fd_sc_hd__fill_1
XTAP_TAPCELL_ROW_0_139 VGND VPWR sky130_fd_sc_hd__tapvpwrvgnd_1
XFILLER_9_81 VPWR VGND VPWR VGND sky130_ef_sc_hd__decap_40_12
XFILLER_0_139 VGND VGND VPWR VPWR sky130_fd_sc_hd__fill_1
XFILLER_56_165 VPWR VGND VPWR VGND sky130_ef_sc_hd__decap_40_12
XFILLER_56_121 VPWR VGND VPWR VGND sky130_ef_sc_hd__decap_40_12
XFILLER_60_77 VGND VGND VPWR VPWR sky130_fd_sc_hd__fill_4
XFILLER_5_39 VPWR VGND VPWR VGND sky130_ef_sc_hd__decap_40_12
XFILLER_4_401 VGND VGND VPWR VPWR sky130_fd_sc_hd__fill_4
XTAP_TAPCELL_ROW_22_296 VGND VPWR sky130_fd_sc_hd__tapvpwrvgnd_1
XPHY_EDGE_ROW_8_Left_73 VGND VGND VPWR VPWR sky130_fd_sc_hd__decap_3
XFILLER_47_165 VGND VGND VPWR VPWR sky130_fd_sc_hd__fill_2
XFILLER_43_393 VPWR VGND VPWR VGND sky130_ef_sc_hd__decap_40_12
XFILLER_7_261 VPWR VGND VPWR VGND sky130_ef_sc_hd__decap_40_12
XTAP_TAPCELL_ROW_13_230 VGND VPWR sky130_fd_sc_hd__tapvpwrvgnd_1
XPHY_EDGE_ROW_7_Right_7 VGND VGND VPWR VPWR sky130_fd_sc_hd__decap_3
XFILLER_53_113 VPWR VGND VPWR VGND sky130_ef_sc_hd__decap_40_12
XFILLER_38_121 VPWR VGND VPWR VGND sky130_ef_sc_hd__decap_40_12
XFILLER_26_305 VGND VGND VPWR VPWR sky130_fd_sc_hd__fill_2
XFILLER_19_390 VGND VGND VPWR VPWR sky130_fd_sc_hd__fill_2
XFILLER_14_15 VPWR VGND VPWR VGND sky130_ef_sc_hd__decap_40_12
XFILLER_55_55 VGND VGND VPWR VPWR sky130_fd_sc_hd__fill_1
XPHY_EDGE_ROW_34_Left_99 VGND VGND VPWR VPWR sky130_fd_sc_hd__decap_3
X_541_ _561_/CLK _541_/D VGND VGND VPWR VPWR _541_/Q sky130_fd_sc_hd__dfxtp_1
XFILLER_29_165 VGND VGND VPWR VPWR sky130_fd_sc_hd__fill_2
XFILLER_17_349 VPWR VGND VPWR VGND sky130_ef_sc_hd__decap_40_12
X_472_ _472_/A _474_/C _474_/D VGND VGND VPWR VPWR _472_/X sky130_fd_sc_hd__and3_1
XTAP_TAPCELL_ROW_10_211 VGND VPWR sky130_fd_sc_hd__tapvpwrvgnd_1
XFILLER_4_253 VPWR VGND VPWR VGND sky130_ef_sc_hd__decap_40_12
XFILLER_35_113 VPWR VGND VPWR VGND sky130_ef_sc_hd__decap_40_12
XTAP_TAPCELL_ROW_33_369 VGND VPWR sky130_fd_sc_hd__tapvpwrvgnd_1
XFILLER_23_308 VGND VGND VPWR VPWR sky130_fd_sc_hd__fill_4
XFILLER_23_319 VGND VGND VPWR VPWR sky130_fd_sc_hd__fill_1
XFILLER_58_249 VGND VGND VPWR VPWR sky130_fd_sc_hd__fill_2
XTAP_TAPCELL_ROW_49_480 VGND VPWR sky130_fd_sc_hd__tapvpwrvgnd_1
XFILLER_41_105 VGND VGND VPWR VPWR sky130_fd_sc_hd__fill_4
XFILLER_25_69 VPWR VGND VPWR VGND sky130_ef_sc_hd__decap_40_12
XFILLER_41_149 VPWR VGND VPWR VGND sky130_ef_sc_hd__decap_40_12
XFILLER_41_57 VPWR VGND VPWR VGND sky130_ef_sc_hd__decap_40_12
XFILLER_49_205 VPWR VGND VPWR VGND sky130_ef_sc_hd__decap_40_12
XFILLER_1_223 VGND VGND VPWR VPWR sky130_fd_sc_hd__fill_1
XFILLER_57_293 VPWR VGND VPWR VGND sky130_ef_sc_hd__decap_40_12
XFILLER_49_249 VPWR VGND VPWR VGND sky130_ef_sc_hd__decap_40_12
XFILLER_2_29 VPWR VGND VPWR VGND sky130_ef_sc_hd__decap_40_12
XFILLER_17_113 VPWR VGND VPWR VGND sky130_ef_sc_hd__decap_40_12
X_386_ _386_/A _386_/B _386_/C VGND VGND VPWR VPWR _386_/X sky130_fd_sc_hd__and3_1
X_524_ _544_/CLK _524_/D VGND VGND VPWR VPWR _524_/Q sky130_fd_sc_hd__dfxtp_1
XFILLER_13_385 VGND VGND VPWR VPWR sky130_fd_sc_hd__fill_4
X_455_ _458_/B _455_/B VGND VGND VPWR VPWR _455_/Y sky130_fd_sc_hd__nand2_1
XFILLER_9_389 VGND VGND VPWR VPWR sky130_fd_sc_hd__fill_2
XTAP_TAPCELL_ROW_46_461 VGND VPWR sky130_fd_sc_hd__tapvpwrvgnd_1
XTAP_TAPCELL_ROW_38_406 VGND VPWR sky130_fd_sc_hd__tapvpwrvgnd_1
XFILLER_23_105 VGND VGND VPWR VPWR sky130_fd_sc_hd__fill_4
XFILLER_23_149 VPWR VGND VPWR VGND sky130_ef_sc_hd__decap_40_12
XFILLER_11_27 VPWR VGND VPWR VGND sky130_ef_sc_hd__decap_40_12
XFILLER_10_333 VPWR VGND VPWR VGND sky130_ef_sc_hd__decap_40_12
XFILLER_10_377 VPWR VGND VPWR VGND sky130_ef_sc_hd__decap_40_12
XFILLER_22_193 VGND VGND VPWR VPWR sky130_fd_sc_hd__fill_2
XFILLER_37_208 VGND VGND VPWR VPWR sky130_fd_sc_hd__fill_4
XFILLER_60_277 VPWR VGND VPWR VGND sky130_ef_sc_hd__decap_40_12
XFILLER_60_233 VPWR VGND VPWR VGND sky130_ef_sc_hd__decap_40_12
XTAP_TAPCELL_ROW_43_442 VGND VPWR sky130_fd_sc_hd__tapvpwrvgnd_1
X_507_ _516_/CLK _507_/D VGND VGND VPWR VPWR _507_/Q sky130_fd_sc_hd__dfxtp_1
X_369_ hold54/X _356_/Y _374_/C _368_/X VGND VGND VPWR VPWR _518_/D sky130_fd_sc_hd__o211a_1
XFILLER_13_193 VPWR VGND VPWR VGND sky130_ef_sc_hd__decap_40_12
X_438_ _442_/B _442_/C VGND VGND VPWR VPWR _440_/C sky130_fd_sc_hd__or2_1
XFILLER_54_3 VPWR VGND VPWR VGND sky130_ef_sc_hd__decap_40_12
XPHY_EDGE_ROW_21_Left_86 VGND VGND VPWR VPWR sky130_fd_sc_hd__decap_3
XFILLER_51_277 VGND VGND VPWR VPWR sky130_fd_sc_hd__fill_2
XFILLER_36_230 VGND VGND VPWR VPWR sky130_fd_sc_hd__fill_1
XFILLER_22_15 VPWR VGND VPWR VGND sky130_ef_sc_hd__decap_40_12
XFILLER_59_333 VGND VGND VPWR VPWR sky130_fd_sc_hd__fill_2
XFILLER_3_329 VGND VGND VPWR VPWR sky130_fd_sc_hd__fill_4
XFILLER_27_241 VGND VGND VPWR VPWR sky130_fd_sc_hd__fill_1
XFILLER_63_55 VGND VGND VPWR VPWR sky130_fd_sc_hd__fill_1
XTAP_TAPCELL_ROW_40_423 VGND VPWR sky130_fd_sc_hd__tapvpwrvgnd_1
XFILLER_10_141 VPWR VGND VPWR VGND sky130_ef_sc_hd__decap_40_12
XFILLER_6_189 VGND VGND VPWR VPWR sky130_fd_sc_hd__fill_4
XFILLER_12_81 VGND VGND VPWR VPWR sky130_fd_sc_hd__fill_2
XFILLER_33_222 VGND VGND VPWR VPWR sky130_fd_sc_hd__fill_2
XFILLER_21_406 VGND VGND VPWR VPWR sky130_fd_sc_hd__fill_1
XTAP_TAPCELL_ROW_54_515 VGND VPWR sky130_fd_sc_hd__tapvpwrvgnd_1
XTAP_TAPCELL_ROW_3_159 VGND VPWR sky130_fd_sc_hd__tapvpwrvgnd_1
XFILLER_17_15 VPWR VGND VPWR VGND sky130_ef_sc_hd__decap_40_12
XFILLER_64_391 VGND VGND VPWR VPWR sky130_fd_sc_hd__fill_1
XFILLER_33_69 VPWR VGND VPWR VGND sky130_ef_sc_hd__decap_40_12
XFILLER_24_299 VGND VGND VPWR VPWR sky130_fd_sc_hd__fill_8
XFILLER_3_137 VPWR VGND VPWR VGND sky130_ef_sc_hd__decap_40_12
XFILLER_58_77 VGND VGND VPWR VPWR sky130_fd_sc_hd__fill_4
XFILLER_55_391 VGND VGND VPWR VPWR sky130_fd_sc_hd__fill_1
XFILLER_15_277 VGND VGND VPWR VPWR sky130_fd_sc_hd__fill_2
XFILLER_30_269 VGND VGND VPWR VPWR sky130_fd_sc_hd__fill_4
XFILLER_53_317 VPWR VGND VPWR VGND sky130_ef_sc_hd__decap_40_12
XFILLER_17_3 VPWR VGND VPWR VGND sky130_ef_sc_hd__decap_40_12
XFILLER_61_361 VPWR VGND VPWR VGND sky130_ef_sc_hd__decap_40_12
XTAP_TAPCELL_ROW_16_250 VGND VPWR sky130_fd_sc_hd__tapvpwrvgnd_1
XFILLER_21_225 VGND VGND VPWR VPWR sky130_fd_sc_hd__fill_8
XFILLER_9_93 VPWR VGND VPWR VGND sky130_ef_sc_hd__decap_40_12
XFILLER_56_177 VPWR VGND VPWR VGND sky130_ef_sc_hd__decap_40_12
XFILLER_56_133 VGND VGND VPWR VPWR sky130_fd_sc_hd__fill_4
XFILLER_52_361 VGND VGND VPWR VPWR sky130_fd_sc_hd__fill_2
XFILLER_44_306 VGND VGND VPWR VPWR sky130_fd_sc_hd__fill_2
XTAP_TAPCELL_ROW_22_297 VGND VPWR sky130_fd_sc_hd__tapvpwrvgnd_1
XFILLER_47_111 VGND VGND VPWR VPWR sky130_fd_sc_hd__fill_1
XFILLER_35_306 VGND VGND VPWR VPWR sky130_fd_sc_hd__fill_2
XFILLER_50_309 VPWR VGND VPWR VGND sky130_ef_sc_hd__decap_40_12
XFILLER_43_361 VPWR VGND VPWR VGND sky130_ef_sc_hd__decap_40_12
XTAP_TAPCELL_ROW_13_231 VGND VPWR sky130_fd_sc_hd__tapvpwrvgnd_1
XFILLER_7_273 VGND VGND VPWR VPWR sky130_fd_sc_hd__fill_4
XFILLER_53_169 VPWR VGND VPWR VGND sky130_ef_sc_hd__decap_40_12
XFILLER_53_125 VPWR VGND VPWR VGND sky130_ef_sc_hd__decap_40_12
XFILLER_38_155 VGND VGND VPWR VPWR sky130_fd_sc_hd__fill_1
XFILLER_38_133 VGND VGND VPWR VPWR sky130_fd_sc_hd__fill_4
Xclkbuf_3_5__f_clk clkbuf_0_clk/X VGND VGND VPWR VPWR _565_/CLK sky130_fd_sc_hd__clkbuf_16
XFILLER_19_380 VGND VGND VPWR VPWR sky130_fd_sc_hd__fill_2
XTAP_TAPCELL_ROW_36_389 VGND VPWR sky130_fd_sc_hd__tapvpwrvgnd_1
XFILLER_14_27 VGND VGND VPWR VPWR sky130_fd_sc_hd__fill_1
XFILLER_30_15 VPWR VGND VPWR VGND sky130_ef_sc_hd__decap_40_12
XFILLER_1_405 VGND VGND VPWR VPWR sky130_fd_sc_hd__fill_2
XFILLER_39_57 VPWR VGND VPWR VGND sky130_ef_sc_hd__decap_40_12
X_540_ _561_/CLK hold2/X VGND VGND VPWR VPWR _540_/Q sky130_fd_sc_hd__dfxtp_1
XFILLER_29_111 VGND VGND VPWR VPWR sky130_fd_sc_hd__fill_1
XFILLER_25_383 VGND VGND VPWR VPWR sky130_fd_sc_hd__fill_1
X_471_ _474_/C _474_/D _472_/A VGND VGND VPWR VPWR _473_/C sky130_fd_sc_hd__a21o_1
XFILLER_4_221 VPWR VGND VPWR VGND sky130_ef_sc_hd__decap_40_12
XTAP_TAPCELL_ROW_10_212 VGND VPWR sky130_fd_sc_hd__tapvpwrvgnd_1
XFILLER_4_265 VPWR VGND VPWR VGND sky130_ef_sc_hd__decap_40_12
XFILLER_20_81 VGND VGND VPWR VPWR sky130_fd_sc_hd__fill_2
Xhold90 _538_/Q VGND VGND VPWR VPWR _427_/B sky130_fd_sc_hd__dlygate4sd3_1
XFILLER_35_147 VGND VGND VPWR VPWR sky130_fd_sc_hd__fill_1
XFILLER_35_125 VPWR VGND VPWR VGND sky130_ef_sc_hd__decap_40_12
XFILLER_50_139 VGND VGND VPWR VPWR sky130_fd_sc_hd__fill_1
XFILLER_16_361 VGND VGND VPWR VPWR sky130_fd_sc_hd__fill_2
XFILLER_6_83 VGND VGND VPWR VPWR sky130_fd_sc_hd__fill_1
XFILLER_54_401 VGND VGND VPWR VPWR sky130_fd_sc_hd__fill_4
XTAP_TAPCELL_ROW_49_481 VGND VPWR sky130_fd_sc_hd__tapvpwrvgnd_1
XANTENNA__358__B _485_/A VGND VGND VPWR VPWR sky130_fd_sc_hd__diode_2
XFILLER_25_15 VPWR VGND VPWR VGND sky130_ef_sc_hd__decap_40_12
XFILLER_14_309 VPWR VGND VPWR VGND sky130_ef_sc_hd__decap_40_12
XFILLER_41_69 VPWR VGND VPWR VGND sky130_ef_sc_hd__decap_40_12
XFILLER_49_217 VGND VGND VPWR VPWR sky130_fd_sc_hd__fill_4
XFILLER_1_279 VGND VGND VPWR VPWR sky130_fd_sc_hd__fill_1
XFILLER_64_209 VGND VGND VPWR VPWR sky130_fd_sc_hd__fill_4
XFILLER_57_261 VPWR VGND VPWR VGND sky130_ef_sc_hd__decap_40_12
X_523_ _523_/CLK _523_/D VGND VGND VPWR VPWR _523_/Q sky130_fd_sc_hd__dfxtp_1
XFILLER_17_125 VPWR VGND VPWR VGND sky130_ef_sc_hd__decap_40_12
XFILLER_17_169 VPWR VGND VPWR VGND sky130_ef_sc_hd__decap_40_12
X_385_ _385_/A _523_/Q _385_/C VGND VGND VPWR VPWR _385_/Y sky130_fd_sc_hd__nand3_1
XFILLER_40_194 VGND VGND VPWR VPWR sky130_fd_sc_hd__fill_2
XFILLER_32_139 VGND VGND VPWR VPWR sky130_fd_sc_hd__fill_1
XFILLER_9_335 VGND VGND VPWR VPWR sky130_fd_sc_hd__fill_1
XFILLER_15_81 VPWR VGND VPWR VGND sky130_ef_sc_hd__decap_40_12
X_454_ _455_/B _481_/A _454_/C VGND VGND VPWR VPWR _454_/X sky130_fd_sc_hd__and3b_1
XTAP_TAPCELL_ROW_38_407 VGND VPWR sky130_fd_sc_hd__tapvpwrvgnd_1
XTAP_TAPCELL_ROW_46_462 VGND VPWR sky130_fd_sc_hd__tapvpwrvgnd_1
XFILLER_31_161 VGND VGND VPWR VPWR sky130_fd_sc_hd__fill_2
XFILLER_11_39 VPWR VGND VPWR VGND sky130_ef_sc_hd__decap_40_12
XFILLER_54_253 VPWR VGND VPWR VGND sky130_ef_sc_hd__decap_40_12
XFILLER_46_209 VPWR VGND VPWR VGND sky130_ef_sc_hd__decap_40_12
XFILLER_39_294 VPWR VGND VPWR VGND sky130_ef_sc_hd__decap_40_12
XFILLER_10_301 VGND VGND VPWR VPWR sky130_fd_sc_hd__fill_4
XFILLER_14_139 VGND VGND VPWR VPWR sky130_fd_sc_hd__fill_1
XFILLER_6_305 VGND VGND VPWR VPWR sky130_fd_sc_hd__fill_2
XFILLER_10_345 VPWR VGND VPWR VGND sky130_ef_sc_hd__decap_40_12
XFILLER_10_389 VPWR VGND VPWR VGND sky130_ef_sc_hd__decap_40_12
XFILLER_60_245 VGND VGND VPWR VPWR sky130_fd_sc_hd__fill_4
XFILLER_45_286 VGND VGND VPWR VPWR sky130_fd_sc_hd__fill_2
XTAP_TAPCELL_ROW_43_443 VGND VPWR sky130_fd_sc_hd__tapvpwrvgnd_1
X_506_ _516_/CLK _506_/D VGND VGND VPWR VPWR _506_/Q sky130_fd_sc_hd__dfxtp_1
XFILLER_60_289 VPWR VGND VPWR VGND sky130_ef_sc_hd__decap_40_12
X_299_ _390_/C _337_/B _288_/Y _428_/A _390_/B VGND VGND VPWR VPWR _544_/D sky130_fd_sc_hd__a32o_1
X_368_ _368_/A _376_/B VGND VGND VPWR VPWR _368_/X sky130_fd_sc_hd__or2_1
XFILLER_9_165 VGND VGND VPWR VPWR sky130_fd_sc_hd__fill_2
XFILLER_13_161 VGND VGND VPWR VPWR sky130_fd_sc_hd__fill_4
XFILLER_20_109 VPWR VGND VPWR VGND sky130_ef_sc_hd__decap_40_12
X_437_ _442_/C _445_/A _437_/C VGND VGND VPWR VPWR _437_/X sky130_fd_sc_hd__and3b_1
XFILLER_47_3 VPWR VGND VPWR VGND sky130_ef_sc_hd__decap_40_12
XFILLER_5_393 VPWR VGND VPWR VGND sky130_ef_sc_hd__decap_40_12
XFILLER_3_51 VGND VGND VPWR VPWR sky130_fd_sc_hd__fill_4
XFILLER_51_223 VGND VGND VPWR VPWR sky130_fd_sc_hd__fill_1
XFILLER_11_109 VGND VGND VPWR VPWR sky130_fd_sc_hd__fill_2
XFILLER_22_27 VGND VGND VPWR VPWR sky130_fd_sc_hd__fill_1
XFILLER_59_389 VGND VGND VPWR VPWR sky130_fd_sc_hd__fill_2
XTAP_TAPCELL_ROW_6_179 VGND VPWR sky130_fd_sc_hd__tapvpwrvgnd_1
XFILLER_47_57 VPWR VGND VPWR VGND sky130_ef_sc_hd__decap_40_12
XPHY_EDGE_ROW_29_Right_29 VGND VGND VPWR VPWR sky130_fd_sc_hd__decap_3
XPHY_EDGE_ROW_38_Right_38 VGND VGND VPWR VPWR sky130_fd_sc_hd__decap_3
XFILLER_8_29 VPWR VGND VPWR VGND sky130_ef_sc_hd__decap_40_12
XFILLER_10_153 VPWR VGND VPWR VGND sky130_ef_sc_hd__decap_40_12
XFILLER_2_363 VGND VGND VPWR VPWR sky130_fd_sc_hd__fill_1
XFILLER_10_197 VPWR VGND VPWR VGND sky130_ef_sc_hd__decap_40_12
XPHY_EDGE_ROW_47_Right_47 VGND VGND VPWR VPWR sky130_fd_sc_hd__decap_3
XPHY_EDGE_ROW_56_Right_56 VGND VGND VPWR VPWR sky130_fd_sc_hd__decap_3
XTAP_TAPCELL_ROW_54_516 VGND VPWR sky130_fd_sc_hd__tapvpwrvgnd_1
XFILLER_17_27 VPWR VGND VPWR VGND sky130_ef_sc_hd__decap_40_12
XTAP_TAPCELL_ROW_19_270 VGND VPWR sky130_fd_sc_hd__tapvpwrvgnd_1
XTAP_TAPCELL_ROW_62_571 VGND VPWR sky130_fd_sc_hd__tapvpwrvgnd_1
XPHY_EDGE_ROW_49_Left_114 VGND VGND VPWR VPWR sky130_fd_sc_hd__decap_3
XFILLER_33_15 VPWR VGND VPWR VGND sky130_ef_sc_hd__decap_40_12
XFILLER_3_149 VPWR VGND VPWR VGND sky130_ef_sc_hd__decap_40_12
XFILLER_3_105 VGND VGND VPWR VPWR sky130_fd_sc_hd__fill_4
XPHY_EDGE_ROW_58_Left_123 VGND VGND VPWR VPWR sky130_fd_sc_hd__decap_3
XFILLER_47_337 VPWR VGND VPWR VGND sky130_ef_sc_hd__decap_40_12
XFILLER_62_307 VGND VGND VPWR VPWR sky130_fd_sc_hd__fill_1
XFILLER_15_223 VGND VGND VPWR VPWR sky130_fd_sc_hd__fill_1
XFILLER_23_81 VPWR VGND VPWR VGND sky130_ef_sc_hd__decap_40_12
XFILLER_2_193 VGND VGND VPWR VPWR sky130_fd_sc_hd__fill_2
XFILLER_53_329 VGND VGND VPWR VPWR sky130_fd_sc_hd__fill_4
XFILLER_0_41 VPWR VGND VPWR VGND sky130_ef_sc_hd__decap_40_12
XFILLER_0_85 VPWR VGND VPWR VGND sky130_ef_sc_hd__decap_40_12
XFILLER_61_373 VPWR VGND VPWR VGND sky130_ef_sc_hd__decap_40_12
XTAP_TAPCELL_ROW_16_251 VGND VPWR sky130_fd_sc_hd__tapvpwrvgnd_1
XANTENNA__305__A2 _283_/X VGND VGND VPWR VPWR sky130_fd_sc_hd__diode_2
XFILLER_28_15 VPWR VGND VPWR VGND sky130_ef_sc_hd__decap_40_12
XFILLER_56_189 VGND VGND VPWR VPWR sky130_fd_sc_hd__fill_4
XFILLER_62_137 VGND VGND VPWR VPWR sky130_fd_sc_hd__fill_2
XFILLER_47_167 VGND VGND VPWR VPWR sky130_fd_sc_hd__fill_1
XFILLER_18_81 VGND VGND VPWR VPWR sky130_fd_sc_hd__fill_2
XFILLER_43_373 VPWR VGND VPWR VGND sky130_ef_sc_hd__decap_40_12
XTAP_TAPCELL_ROW_13_232 VGND VPWR sky130_fd_sc_hd__tapvpwrvgnd_1
XFILLER_11_281 VPWR VGND VPWR VGND sky130_ef_sc_hd__decap_40_12
XFILLER_53_137 VPWR VGND VPWR VGND sky130_ef_sc_hd__decap_40_12
XFILLER_26_307 VGND VGND VPWR VPWR sky130_fd_sc_hd__fill_1
XFILLER_61_181 VPWR VGND VPWR VGND sky130_ef_sc_hd__decap_40_12
XFILLER_30_27 VGND VGND VPWR VPWR sky130_fd_sc_hd__fill_1
XFILLER_55_57 VPWR VGND VPWR VGND sky130_ef_sc_hd__decap_40_12
XFILLER_44_137 VGND VGND VPWR VPWR sky130_fd_sc_hd__fill_2
XFILLER_39_69 VPWR VGND VPWR VGND sky130_ef_sc_hd__decap_40_12
XFILLER_29_167 VGND VGND VPWR VPWR sky130_fd_sc_hd__fill_1
XFILLER_40_365 VGND VGND VPWR VPWR sky130_fd_sc_hd__fill_2
X_470_ _474_/C _474_/D _469_/Y VGND VGND VPWR VPWR _470_/Y sky130_fd_sc_hd__a21oi_1
XFILLER_4_233 VPWR VGND VPWR VGND sky130_ef_sc_hd__decap_40_12
XTAP_TAPCELL_ROW_10_213 VGND VPWR sky130_fd_sc_hd__tapvpwrvgnd_1
XFILLER_4_277 VPWR VGND VPWR VGND sky130_ef_sc_hd__decap_40_12
Xhold91 _425_/Y VGND VGND VPWR VPWR _538_/D sky130_fd_sc_hd__dlygate4sd3_1
XFILLER_35_137 VGND VGND VPWR VPWR sky130_fd_sc_hd__fill_8
Xhold80 _303_/X VGND VGND VPWR VPWR _491_/D sky130_fd_sc_hd__dlygate4sd3_1
XFILLER_43_181 VPWR VGND VPWR VGND sky130_ef_sc_hd__decap_40_12
XFILLER_31_332 VGND VGND VPWR VPWR sky130_fd_sc_hd__fill_4
XTAP_TAPCELL_ROW_49_482 VGND VPWR sky130_fd_sc_hd__tapvpwrvgnd_1
XFILLER_26_137 VGND VGND VPWR VPWR sky130_fd_sc_hd__fill_2
XFILLER_25_27 VPWR VGND VPWR VGND sky130_ef_sc_hd__decap_40_12
XTAP_TAPCELL_ROW_24_305 VGND VPWR sky130_fd_sc_hd__tapvpwrvgnd_1
XFILLER_41_15 VPWR VGND VPWR VGND sky130_ef_sc_hd__decap_40_12
XANTENNA_clkbuf_3_5__f_clk_A clkbuf_0_clk/X VGND VGND VPWR VPWR sky130_fd_sc_hd__diode_2
XFILLER_1_225 VPWR VGND VPWR VGND sky130_ef_sc_hd__decap_40_12
XFILLER_60_405 VGND VGND VPWR VPWR sky130_fd_sc_hd__fill_2
XFILLER_57_273 VGND VGND VPWR VPWR sky130_fd_sc_hd__fill_4
X_522_ _544_/CLK _522_/D VGND VGND VPWR VPWR _522_/Q sky130_fd_sc_hd__dfxtp_1
XFILLER_17_137 VPWR VGND VPWR VGND sky130_ef_sc_hd__decap_40_12
X_453_ _458_/C _458_/D VGND VGND VPWR VPWR _455_/B sky130_fd_sc_hd__and2_1
X_384_ _523_/Q _385_/C _385_/A VGND VGND VPWR VPWR _386_/B sky130_fd_sc_hd__a21o_1
XFILLER_25_181 VGND VGND VPWR VPWR sky130_fd_sc_hd__fill_1
XFILLER_15_93 VPWR VGND VPWR VGND sky130_ef_sc_hd__decap_40_12
XFILLER_31_81 VPWR VGND VPWR VGND sky130_ef_sc_hd__decap_40_12
XFILLER_63_221 VGND VGND VPWR VPWR sky130_fd_sc_hd__fill_2
XFILLER_48_251 VGND VGND VPWR VPWR sky130_fd_sc_hd__fill_1
XTAP_TAPCELL_ROW_38_408 VGND VPWR sky130_fd_sc_hd__tapvpwrvgnd_1
XFILLER_51_405 VGND VGND VPWR VPWR sky130_fd_sc_hd__fill_2
XTAP_TAPCELL_ROW_46_463 VGND VPWR sky130_fd_sc_hd__tapvpwrvgnd_1
XFILLER_54_265 VPWR VGND VPWR VGND sky130_ef_sc_hd__decap_40_12
XFILLER_54_221 VPWR VGND VPWR VGND sky130_ef_sc_hd__decap_40_12
XFILLER_36_15 VPWR VGND VPWR VGND sky130_ef_sc_hd__decap_40_12
XFILLER_10_357 VGND VGND VPWR VPWR sky130_fd_sc_hd__fill_4
XFILLER_22_195 VGND VGND VPWR VPWR sky130_fd_sc_hd__fill_1
XFILLER_7_3 VPWR VGND VPWR VGND sky130_ef_sc_hd__decap_40_12
XFILLER_45_221 VGND VGND VPWR VPWR sky130_fd_sc_hd__fill_2
XTAP_TAPCELL_ROW_43_444 VGND VPWR sky130_fd_sc_hd__tapvpwrvgnd_1
X_505_ _516_/CLK _505_/D VGND VGND VPWR VPWR _505_/Q sky130_fd_sc_hd__dfxtp_1
XFILLER_26_81 VGND VGND VPWR VPWR sky130_fd_sc_hd__fill_2
X_436_ _436_/A _436_/B _447_/C VGND VGND VPWR VPWR _442_/C sky130_fd_sc_hd__and3_1
X_367_ _368_/A _356_/Y _374_/C _366_/X VGND VGND VPWR VPWR _367_/X sky130_fd_sc_hd__o211a_1
XFILLER_9_111 VGND VGND VPWR VPWR sky130_fd_sc_hd__fill_1
X_298_ _337_/B _333_/A _481_/A _447_/B VGND VGND VPWR VPWR _298_/X sky130_fd_sc_hd__a22o_1
XFILLER_5_361 VPWR VGND VPWR VGND sky130_ef_sc_hd__decap_40_12
XFILLER_36_210 VGND VGND VPWR VPWR sky130_fd_sc_hd__fill_2
XFILLER_51_279 VGND VGND VPWR VPWR sky130_fd_sc_hd__fill_1
XFILLER_59_335 VGND VGND VPWR VPWR sky130_fd_sc_hd__fill_1
XTAP_TAPCELL_ROW_57_536 VGND VPWR sky130_fd_sc_hd__tapvpwrvgnd_1
XFILLER_47_69 VPWR VGND VPWR VGND sky130_ef_sc_hd__decap_40_12
XFILLER_63_57 VPWR VGND VPWR VGND sky130_ef_sc_hd__decap_40_12
XANTENNA__271__C1 _485_/A VGND VGND VPWR VPWR sky130_fd_sc_hd__diode_2
XFILLER_15_405 VGND VGND VPWR VPWR sky130_fd_sc_hd__fill_2
XFILLER_10_121 VPWR VGND VPWR VGND sky130_ef_sc_hd__decap_40_12
XFILLER_10_165 VPWR VGND VPWR VGND sky130_ef_sc_hd__decap_40_12
XFILLER_12_83 VGND VGND VPWR VPWR sky130_fd_sc_hd__fill_1
XFILLER_33_202 VGND VGND VPWR VPWR sky130_fd_sc_hd__fill_2
XFILLER_18_221 VPWR VGND VPWR VGND sky130_ef_sc_hd__decap_40_12
X_419_ _421_/B _417_/A _428_/A VGND VGND VPWR VPWR _419_/Y sky130_fd_sc_hd__o21ai_1
XFILLER_56_305 VGND VGND VPWR VPWR sky130_fd_sc_hd__fill_2
XFILLER_64_393 VPWR VGND VPWR VGND sky130_ef_sc_hd__decap_40_12
XTAP_TAPCELL_ROW_54_517 VGND VPWR sky130_fd_sc_hd__tapvpwrvgnd_1
XFILLER_17_39 VPWR VGND VPWR VGND sky130_ef_sc_hd__decap_40_12
XTAP_TAPCELL_ROW_19_271 VGND VPWR sky130_fd_sc_hd__tapvpwrvgnd_1
XTAP_TAPCELL_ROW_62_572 VGND VPWR sky130_fd_sc_hd__tapvpwrvgnd_1
XANTENNA__308__B1 _485_/A VGND VGND VPWR VPWR sky130_fd_sc_hd__diode_2
XFILLER_33_27 VPWR VGND VPWR VGND sky130_ef_sc_hd__decap_40_12
XFILLER_59_165 VGND VGND VPWR VPWR sky130_fd_sc_hd__fill_2
XFILLER_47_349 VPWR VGND VPWR VGND sky130_ef_sc_hd__decap_40_12
XFILLER_47_305 VPWR VGND VPWR VGND sky130_ef_sc_hd__decap_40_12
XFILLER_55_393 VPWR VGND VPWR VGND sky130_ef_sc_hd__decap_40_12
XFILLER_15_279 VGND VGND VPWR VPWR sky130_fd_sc_hd__fill_1
XFILLER_23_93 VPWR VGND VPWR VGND sky130_ef_sc_hd__decap_40_12
XFILLER_0_53 VGND VGND VPWR VPWR sky130_fd_sc_hd__fill_2
XFILLER_0_97 VPWR VGND VPWR VGND sky130_ef_sc_hd__decap_40_12
XFILLER_61_385 VGND VGND VPWR VPWR sky130_fd_sc_hd__fill_4
XFILLER_9_51 VGND VGND VPWR VPWR sky130_fd_sc_hd__fill_4
XTAP_TAPCELL_ROW_16_252 VGND VPWR sky130_fd_sc_hd__tapvpwrvgnd_1
XFILLER_21_205 VPWR VGND VPWR VGND sky130_ef_sc_hd__decap_40_12
XFILLER_0_109 VGND VGND VPWR VPWR sky130_fd_sc_hd__fill_2
XFILLER_28_27 VGND VGND VPWR VPWR sky130_fd_sc_hd__fill_1
XFILLER_52_363 VGND VGND VPWR VPWR sky130_fd_sc_hd__fill_1
XFILLER_44_15 VPWR VGND VPWR VGND sky130_ef_sc_hd__decap_40_12
XFILLER_37_393 VGND VGND VPWR VPWR sky130_fd_sc_hd__fill_1
XFILLER_8_209 VPWR VGND VPWR VGND sky130_ef_sc_hd__decap_40_12
XFILLER_12_249 VGND VGND VPWR VPWR sky130_fd_sc_hd__fill_2
XFILLER_20_271 VGND VGND VPWR VPWR sky130_fd_sc_hd__fill_2
XFILLER_47_113 VPWR VGND VPWR VGND sky130_ef_sc_hd__decap_40_12
XFILLER_35_308 VGND VGND VPWR VPWR sky130_fd_sc_hd__fill_1
XFILLER_28_382 VGND VGND VPWR VPWR sky130_fd_sc_hd__fill_1
XFILLER_43_385 VGND VGND VPWR VPWR sky130_fd_sc_hd__fill_4
XFILLER_34_81 VGND VGND VPWR VPWR sky130_fd_sc_hd__fill_2
XFILLER_11_293 VPWR VGND VPWR VGND sky130_ef_sc_hd__decap_40_12
XTAP_TAPCELL_ROW_13_233 VGND VPWR sky130_fd_sc_hd__tapvpwrvgnd_1
XANTENNA__299__A2 _337_/B VGND VGND VPWR VPWR sky130_fd_sc_hd__diode_2
XFILLER_53_105 VGND VGND VPWR VPWR sky130_fd_sc_hd__fill_4
XFILLER_22_3 VPWR VGND VPWR VGND sky130_ef_sc_hd__decap_40_12
XFILLER_61_193 VPWR VGND VPWR VGND sky130_ef_sc_hd__decap_40_12
XFILLER_53_149 VPWR VGND VPWR VGND sky130_ef_sc_hd__decap_40_12
XFILLER_34_363 VGND VGND VPWR VPWR sky130_fd_sc_hd__fill_1
XFILLER_34_352 VGND VGND VPWR VPWR sky130_fd_sc_hd__fill_1
XFILLER_14_29 VPWR VGND VPWR VGND sky130_ef_sc_hd__decap_40_12
XFILLER_39_15 VPWR VGND VPWR VGND sky130_ef_sc_hd__decap_40_12
XFILLER_55_69 VPWR VGND VPWR VGND sky130_ef_sc_hd__decap_40_12
XFILLER_29_113 VPWR VGND VPWR VGND sky130_ef_sc_hd__decap_40_12
XFILLER_52_193 VGND VGND VPWR VPWR sky130_fd_sc_hd__fill_2
XFILLER_40_388 VGND VGND VPWR VPWR sky130_fd_sc_hd__fill_2
XFILLER_40_355 VGND VGND VPWR VPWR sky130_fd_sc_hd__fill_1
XFILLER_25_363 VGND VGND VPWR VPWR sky130_fd_sc_hd__fill_1
XFILLER_4_289 VPWR VGND VPWR VGND sky130_ef_sc_hd__decap_40_12
XFILLER_4_245 VGND VGND VPWR VPWR sky130_fd_sc_hd__fill_4
XFILLER_20_83 VGND VGND VPWR VPWR sky130_fd_sc_hd__fill_1
Xhold92 _499_/Q VGND VGND VPWR VPWR hold92/X sky130_fd_sc_hd__dlygate4sd3_1
Xhold70 _500_/Q VGND VGND VPWR VPWR hold70/X sky130_fd_sc_hd__dlygate4sd3_1
XFILLER_29_81 VPWR VGND VPWR VGND sky130_ef_sc_hd__decap_40_12
Xhold81 _556_/Q VGND VGND VPWR VPWR _466_/C sky130_fd_sc_hd__dlygate4sd3_1
XFILLER_43_193 VGND VGND VPWR VPWR sky130_fd_sc_hd__fill_8
XFILLER_35_105 VGND VGND VPWR VPWR sky130_fd_sc_hd__fill_4
XFILLER_16_363 VGND VGND VPWR VPWR sky130_fd_sc_hd__fill_1
XANTENNA_1 _430_/B VGND VGND VPWR VPWR sky130_fd_sc_hd__diode_2
XFILLER_6_41 VPWR VGND VPWR VGND sky130_ef_sc_hd__decap_40_12
XFILLER_6_85 VPWR VGND VPWR VGND sky130_ef_sc_hd__decap_40_12
XTAP_TAPCELL_ROW_49_483 VGND VPWR sky130_fd_sc_hd__tapvpwrvgnd_1
XFILLER_41_27 VPWR VGND VPWR VGND sky130_ef_sc_hd__decap_40_12
XTAP_TAPCELL_ROW_32_361 VGND VPWR sky130_fd_sc_hd__tapvpwrvgnd_1
XFILLER_25_39 VPWR VGND VPWR VGND sky130_ef_sc_hd__decap_40_12
XFILLER_22_333 VGND VGND VPWR VPWR sky130_fd_sc_hd__fill_2
XTAP_TAPCELL_ROW_24_306 VGND VPWR sky130_fd_sc_hd__tapvpwrvgnd_1
XFILLER_1_237 VPWR VGND VPWR VGND sky130_ef_sc_hd__decap_40_12
X_383_ _386_/A _383_/B _383_/C VGND VGND VPWR VPWR _523_/D sky130_fd_sc_hd__and3_1
X_521_ _523_/CLK _521_/D VGND VGND VPWR VPWR _521_/Q sky130_fd_sc_hd__dfxtp_1
XFILLER_13_333 VGND VGND VPWR VPWR sky130_fd_sc_hd__fill_2
XFILLER_17_105 VGND VGND VPWR VPWR sky130_fd_sc_hd__fill_4
XFILLER_17_149 VPWR VGND VPWR VGND sky130_ef_sc_hd__decap_40_12
X_452_ _452_/A _452_/B VGND VGND VPWR VPWR _458_/D sky130_fd_sc_hd__and2_1
XFILLER_40_141 VPWR VGND VPWR VGND sky130_ef_sc_hd__decap_40_12
XFILLER_9_337 VPWR VGND VPWR VGND sky130_ef_sc_hd__decap_40_12
Xoutput3 hold7/A VGND VGND VPWR VPWR led[0] sky130_fd_sc_hd__buf_2
XFILLER_31_93 VPWR VGND VPWR VGND sky130_ef_sc_hd__decap_40_12
XTAP_TAPCELL_ROW_38_409 VGND VPWR sky130_fd_sc_hd__tapvpwrvgnd_1
XFILLER_0_281 VPWR VGND VPWR VGND sky130_ef_sc_hd__decap_40_12
XFILLER_63_277 VGND VGND VPWR VPWR sky130_fd_sc_hd__fill_2
XTAP_TAPCELL_ROW_46_464 VGND VPWR sky130_fd_sc_hd__tapvpwrvgnd_1
XFILLER_31_163 VGND VGND VPWR VPWR sky130_fd_sc_hd__fill_1
XFILLER_16_193 VGND VGND VPWR VPWR sky130_fd_sc_hd__fill_2
XFILLER_31_196 VGND VGND VPWR VPWR sky130_fd_sc_hd__fill_4
XFILLER_54_277 VPWR VGND VPWR VGND sky130_ef_sc_hd__decap_40_12
XFILLER_54_233 VPWR VGND VPWR VGND sky130_ef_sc_hd__decap_40_12
XFILLER_52_15 VPWR VGND VPWR VGND sky130_ef_sc_hd__decap_40_12
XFILLER_39_274 VGND VGND VPWR VPWR sky130_fd_sc_hd__fill_4
XFILLER_36_27 VGND VGND VPWR VPWR sky130_fd_sc_hd__fill_1
XFILLER_6_307 VGND VGND VPWR VPWR sky130_fd_sc_hd__fill_1
XFILLER_22_141 VPWR VGND VPWR VGND sky130_ef_sc_hd__decap_40_12
X_366_ _366_/A _376_/B VGND VGND VPWR VPWR _366_/X sky130_fd_sc_hd__or2_1
X_504_ _564_/CLK _504_/D VGND VGND VPWR VPWR _504_/Q sky130_fd_sc_hd__dfxtp_1
X_435_ _436_/B _447_/C _436_/A VGND VGND VPWR VPWR _435_/X sky130_fd_sc_hd__a21o_1
XFILLER_42_81 VGND VGND VPWR VPWR sky130_fd_sc_hd__fill_2
X_297_ _485_/A _436_/B VGND VGND VPWR VPWR _481_/A sky130_fd_sc_hd__nor2_4
XFILLER_5_373 VPWR VGND VPWR VGND sky130_ef_sc_hd__decap_40_12
XFILLER_9_167 VGND VGND VPWR VPWR sky130_fd_sc_hd__fill_1
XFILLER_51_225 VPWR VGND VPWR VGND sky130_ef_sc_hd__decap_40_12
XFILLER_36_277 VGND VGND VPWR VPWR sky130_fd_sc_hd__fill_4
XFILLER_22_29 VPWR VGND VPWR VGND sky130_ef_sc_hd__decap_40_12
XTAP_TAPCELL_ROW_57_537 VGND VPWR sky130_fd_sc_hd__tapvpwrvgnd_1
XFILLER_47_15 VPWR VGND VPWR VGND sky130_ef_sc_hd__decap_40_12
XFILLER_27_222 VGND VGND VPWR VPWR sky130_fd_sc_hd__fill_2
XANTENNA_input1_A sw_0 VGND VGND VPWR VPWR sky130_fd_sc_hd__diode_2
XFILLER_63_69 VPWR VGND VPWR VGND sky130_ef_sc_hd__decap_40_12
XFILLER_6_137 VGND VGND VPWR VPWR sky130_fd_sc_hd__fill_2
XFILLER_10_133 VGND VGND VPWR VPWR sky130_fd_sc_hd__fill_4
XFILLER_10_177 VPWR VGND VPWR VGND sky130_ef_sc_hd__decap_40_12
XFILLER_2_365 VPWR VGND VPWR VGND sky130_ef_sc_hd__decap_40_12
XFILLER_2_321 VPWR VGND VPWR VGND sky130_ef_sc_hd__decap_40_12
XFILLER_37_81 VPWR VGND VPWR VGND sky130_ef_sc_hd__decap_40_12
XFILLER_33_225 VGND VGND VPWR VPWR sky130_fd_sc_hd__fill_2
XFILLER_18_233 VPWR VGND VPWR VGND sky130_ef_sc_hd__decap_40_12
X_418_ _421_/B _535_/Q _421_/D VGND VGND VPWR VPWR _420_/A sky130_fd_sc_hd__and3_1
X_349_ _390_/B _510_/Q VGND VGND VPWR VPWR _349_/X sky130_fd_sc_hd__or2_1
XFILLER_52_3 VPWR VGND VPWR VGND sky130_ef_sc_hd__decap_40_12
XFILLER_5_181 VPWR VGND VPWR VGND sky130_ef_sc_hd__decap_40_12
XFILLER_49_391 VGND VGND VPWR VPWR sky130_fd_sc_hd__fill_1
XFILLER_64_361 VGND VGND VPWR VPWR sky130_fd_sc_hd__fill_2
XTAP_TAPCELL_ROW_62_573 VGND VPWR sky130_fd_sc_hd__tapvpwrvgnd_1
XTAP_TAPCELL_ROW_54_518 VGND VPWR sky130_fd_sc_hd__tapvpwrvgnd_1
XFILLER_33_39 VPWR VGND VPWR VGND sky130_ef_sc_hd__decap_40_12
XTAP_TAPCELL_ROW_19_272 VGND VPWR sky130_fd_sc_hd__tapvpwrvgnd_1
XFILLER_59_111 VGND VGND VPWR VPWR sky130_fd_sc_hd__fill_1
XFILLER_62_309 VPWR VGND VPWR VGND sky130_ef_sc_hd__decap_40_12
XFILLER_55_361 VPWR VGND VPWR VGND sky130_ef_sc_hd__decap_40_12
XFILLER_47_317 VPWR VGND VPWR VGND sky130_ef_sc_hd__decap_40_12
XTAP_TAPCELL_ROW_2_151 VGND VPWR sky130_fd_sc_hd__tapvpwrvgnd_1
XFILLER_15_225 VPWR VGND VPWR VGND sky130_ef_sc_hd__decap_40_12
XFILLER_2_195 VGND VGND VPWR VPWR sky130_fd_sc_hd__fill_1
XFILLER_46_361 VGND VGND VPWR VPWR sky130_fd_sc_hd__fill_2
XTAP_TAPCELL_ROW_16_253 VGND VPWR sky130_fd_sc_hd__tapvpwrvgnd_1
XFILLER_21_217 VGND VGND VPWR VPWR sky130_fd_sc_hd__fill_4
XFILLER_44_309 VPWR VGND VPWR VGND sky130_ef_sc_hd__decap_40_12
XFILLER_60_15 VPWR VGND VPWR VGND sky130_ef_sc_hd__decap_40_12
XFILLER_44_27 VGND VGND VPWR VPWR sky130_fd_sc_hd__fill_1
XFILLER_4_405 VGND VGND VPWR VPWR sky130_fd_sc_hd__fill_2
XFILLER_47_125 VPWR VGND VPWR VGND sky130_ef_sc_hd__decap_40_12
XFILLER_62_139 VGND VGND VPWR VPWR sky130_fd_sc_hd__fill_1
XFILLER_47_169 VPWR VGND VPWR VGND sky130_ef_sc_hd__decap_40_12
XFILLER_43_320 VGND VGND VPWR VPWR sky130_fd_sc_hd__fill_8
XFILLER_18_83 VGND VGND VPWR VPWR sky130_fd_sc_hd__fill_1
XFILLER_7_221 VGND VGND VPWR VPWR sky130_fd_sc_hd__fill_2
XFILLER_11_261 VPWR VGND VPWR VGND sky130_ef_sc_hd__decap_40_12
XTAP_TAPCELL_ROW_13_234 VGND VPWR sky130_fd_sc_hd__tapvpwrvgnd_1
XFILLER_50_81 VGND VGND VPWR VPWR sky130_fd_sc_hd__fill_2
XFILLER_15_3 VPWR VGND VPWR VGND sky130_ef_sc_hd__decap_40_12
XFILLER_19_361 VGND VGND VPWR VPWR sky130_fd_sc_hd__fill_8
XFILLER_61_161 VGND VGND VPWR VPWR sky130_fd_sc_hd__fill_4
XPHY_EDGE_ROW_28_Left_93 VGND VGND VPWR VPWR sky130_fd_sc_hd__decap_3
XFILLER_30_29 VPWR VGND VPWR VGND sky130_ef_sc_hd__decap_40_12
XPHY_EDGE_ROW_12_Left_77 VGND VGND VPWR VPWR sky130_fd_sc_hd__decap_3
XFILLER_39_27 VPWR VGND VPWR VGND sky130_ef_sc_hd__decap_40_12
XFILLER_29_125 VPWR VGND VPWR VGND sky130_ef_sc_hd__decap_40_12
XFILLER_55_15 VPWR VGND VPWR VGND sky130_ef_sc_hd__decap_40_12
XFILLER_44_139 VGND VGND VPWR VPWR sky130_fd_sc_hd__fill_1
XTAP_TAPCELL_ROW_27_326 VGND VPWR sky130_fd_sc_hd__tapvpwrvgnd_1
XFILLER_40_367 VGND VGND VPWR VPWR sky130_fd_sc_hd__fill_1
XFILLER_48_401 VGND VGND VPWR VPWR sky130_fd_sc_hd__fill_4
Xhold60 _304_/X VGND VGND VPWR VPWR hold60/X sky130_fd_sc_hd__dlygate4sd3_1
Xhold71 _323_/X VGND VGND VPWR VPWR _324_/B sky130_fd_sc_hd__dlygate4sd3_1
Xhold93 _320_/X VGND VGND VPWR VPWR _321_/B sky130_fd_sc_hd__dlygate4sd3_1
XFILLER_29_93 VPWR VGND VPWR VGND sky130_ef_sc_hd__decap_40_12
Xhold82 _461_/Y VGND VGND VPWR VPWR _462_/B sky130_fd_sc_hd__dlygate4sd3_1
XFILLER_50_109 VPWR VGND VPWR VGND sky130_ef_sc_hd__decap_40_12
XFILLER_45_81 VPWR VGND VPWR VGND sky130_ef_sc_hd__decap_40_12
XFILLER_43_161 VGND VGND VPWR VPWR sky130_fd_sc_hd__fill_4
XFILLER_31_389 VGND VGND VPWR VPWR sky130_fd_sc_hd__fill_1
XFILLER_6_53 VPWR VGND VPWR VGND sky130_ef_sc_hd__decap_40_12
XFILLER_58_209 VPWR VGND VPWR VGND sky130_ef_sc_hd__decap_40_12
XFILLER_39_401 VGND VGND VPWR VPWR sky130_fd_sc_hd__fill_2
XFILLER_6_97 VPWR VGND VPWR VGND sky130_ef_sc_hd__decap_40_12
XTAP_TAPCELL_ROW_49_484 VGND VPWR sky130_fd_sc_hd__tapvpwrvgnd_1
XFILLER_41_109 VGND VGND VPWR VPWR sky130_fd_sc_hd__fill_2
XFILLER_26_139 VGND VGND VPWR VPWR sky130_fd_sc_hd__fill_1
XTAP_TAPCELL_ROW_24_307 VGND VPWR sky130_fd_sc_hd__tapvpwrvgnd_1
XFILLER_41_39 VPWR VGND VPWR VGND sky130_ef_sc_hd__decap_40_12
XTAP_TAPCELL_ROW_32_362 VGND VPWR sky130_fd_sc_hd__tapvpwrvgnd_1
XFILLER_1_205 VPWR VGND VPWR VGND sky130_ef_sc_hd__decap_40_12
XFILLER_1_249 VPWR VGND VPWR VGND sky130_ef_sc_hd__decap_40_12
X_520_ _544_/CLK _520_/D VGND VGND VPWR VPWR _520_/Q sky130_fd_sc_hd__dfxtp_1
X_382_ _382_/A _385_/C VGND VGND VPWR VPWR _383_/C sky130_fd_sc_hd__nand2_1
XFILLER_40_153 VPWR VGND VPWR VGND sky130_ef_sc_hd__decap_40_12
XFILLER_32_109 VPWR VGND VPWR VGND sky130_ef_sc_hd__decap_40_12
XFILLER_25_161 VGND VGND VPWR VPWR sky130_fd_sc_hd__fill_4
XFILLER_9_305 VPWR VGND VPWR VGND sky130_ef_sc_hd__decap_40_12
XFILLER_15_51 VGND VGND VPWR VPWR sky130_fd_sc_hd__fill_4
X_451_ _452_/B _458_/C _452_/A VGND VGND VPWR VPWR _451_/X sky130_fd_sc_hd__a21o_1
XFILLER_9_349 VPWR VGND VPWR VGND sky130_ef_sc_hd__decap_40_12
XFILLER_13_389 VGND VGND VPWR VPWR sky130_fd_sc_hd__fill_2
Xoutput4 _491_/Q VGND VGND VPWR VPWR led[1] sky130_fd_sc_hd__buf_2
XFILLER_63_223 VGND VGND VPWR VPWR sky130_fd_sc_hd__fill_1
XFILLER_48_253 VPWR VGND VPWR VGND sky130_ef_sc_hd__decap_40_12
XTAP_TAPCELL_ROW_46_465 VGND VPWR sky130_fd_sc_hd__tapvpwrvgnd_1
XFILLER_0_293 VPWR VGND VPWR VGND sky130_ef_sc_hd__decap_40_12
XFILLER_23_109 VGND VGND VPWR VPWR sky130_fd_sc_hd__fill_2
XFILLER_54_289 VPWR VGND VPWR VGND sky130_ef_sc_hd__decap_40_12
XFILLER_54_245 VGND VGND VPWR VPWR sky130_fd_sc_hd__fill_4
XFILLER_52_27 VGND VGND VPWR VPWR sky130_fd_sc_hd__fill_1
XFILLER_14_109 VPWR VGND VPWR VGND sky130_ef_sc_hd__decap_40_12
XFILLER_22_153 VPWR VGND VPWR VGND sky130_ef_sc_hd__decap_40_12
XFILLER_22_197 VPWR VGND VPWR VGND sky130_ef_sc_hd__decap_40_12
XPHY_EDGE_ROW_15_Left_80 VGND VGND VPWR VPWR sky130_fd_sc_hd__decap_3
XFILLER_45_223 VGND VGND VPWR VPWR sky130_fd_sc_hd__fill_1
X_503_ _523_/CLK _503_/D VGND VGND VPWR VPWR _503_/Q sky130_fd_sc_hd__dfxtp_1
X_365_ _366_/A _356_/Y _374_/C hold38/X VGND VGND VPWR VPWR _365_/X sky130_fd_sc_hd__o211a_1
X_296_ _486_/Q _306_/B VGND VGND VPWR VPWR _337_/C sky130_fd_sc_hd__nand2_2
XFILLER_26_83 VGND VGND VPWR VPWR sky130_fd_sc_hd__fill_1
XFILLER_9_113 VPWR VGND VPWR VGND sky130_ef_sc_hd__decap_40_12
X_434_ _434_/A _434_/B VGND VGND VPWR VPWR _447_/C sky130_fd_sc_hd__or2_1
XFILLER_5_385 VGND VGND VPWR VPWR sky130_fd_sc_hd__fill_4
XFILLER_51_237 VPWR VGND VPWR VGND sky130_ef_sc_hd__decap_40_12
XFILLER_59_337 VPWR VGND VPWR VGND sky130_ef_sc_hd__decap_40_12
XFILLER_63_15 VPWR VGND VPWR VGND sky130_ef_sc_hd__decap_40_12
XTAP_TAPCELL_ROW_57_538 VGND VPWR sky130_fd_sc_hd__tapvpwrvgnd_1
XFILLER_47_27 VPWR VGND VPWR VGND sky130_ef_sc_hd__decap_40_12
XFILLER_27_289 VGND VGND VPWR VPWR sky130_fd_sc_hd__fill_2
XFILLER_27_278 VGND VGND VPWR VPWR sky130_fd_sc_hd__fill_2
XFILLER_10_189 VGND VGND VPWR VPWR sky130_fd_sc_hd__fill_4
XFILLER_12_41 VPWR VGND VPWR VGND sky130_ef_sc_hd__decap_40_12
XFILLER_12_85 VPWR VGND VPWR VGND sky130_ef_sc_hd__decap_40_12
XFILLER_2_377 VPWR VGND VPWR VGND sky130_ef_sc_hd__decap_40_12
XFILLER_2_333 VPWR VGND VPWR VGND sky130_ef_sc_hd__decap_40_12
XPHY_EDGE_ROW_0_Left_65 VGND VGND VPWR VPWR sky130_fd_sc_hd__decap_3
XFILLER_37_93 VPWR VGND VPWR VGND sky130_ef_sc_hd__decap_40_12
XFILLER_33_204 VGND VGND VPWR VPWR sky130_fd_sc_hd__fill_1
XPHY_EDGE_ROW_16_Right_16 VGND VGND VPWR VPWR sky130_fd_sc_hd__decap_3
XFILLER_18_245 VGND VGND VPWR VPWR sky130_fd_sc_hd__fill_4
XFILLER_53_81 VPWR VGND VPWR VGND sky130_ef_sc_hd__decap_40_12
X_417_ _417_/A _417_/B VGND VGND VPWR VPWR _417_/Y sky130_fd_sc_hd__nor2_1
X_348_ _366_/A _374_/A _337_/B _347_/X VGND VGND VPWR VPWR _348_/X sky130_fd_sc_hd__o211a_1
XPHY_EDGE_ROW_25_Right_25 VGND VGND VPWR VPWR sky130_fd_sc_hd__decap_3
X_279_ _273_/A _447_/B _436_/B _273_/X VGND VGND VPWR VPWR _279_/X sky130_fd_sc_hd__a31o_1
XFILLER_45_3 VPWR VGND VPWR VGND sky130_ef_sc_hd__decap_40_12
XFILLER_5_193 VPWR VGND VPWR VGND sky130_ef_sc_hd__decap_40_12
XFILLER_56_307 VGND VGND VPWR VPWR sky130_fd_sc_hd__fill_1
XPHY_EDGE_ROW_34_Right_34 VGND VGND VPWR VPWR sky130_fd_sc_hd__decap_3
XTAP_TAPCELL_ROW_62_574 VGND VPWR sky130_fd_sc_hd__tapvpwrvgnd_1
XTAP_TAPCELL_ROW_54_519 VGND VPWR sky130_fd_sc_hd__tapvpwrvgnd_1
XFILLER_32_270 VGND VGND VPWR VPWR sky130_fd_sc_hd__fill_2
XTAP_TAPCELL_ROW_19_273 VGND VPWR sky130_fd_sc_hd__tapvpwrvgnd_1
XPHY_EDGE_ROW_43_Right_43 VGND VGND VPWR VPWR sky130_fd_sc_hd__decap_3
XFILLER_59_167 VGND VGND VPWR VPWR sky130_fd_sc_hd__fill_1
XFILLER_58_15 VPWR VGND VPWR VGND sky130_ef_sc_hd__decap_40_12
XPHY_EDGE_ROW_52_Right_52 VGND VGND VPWR VPWR sky130_fd_sc_hd__decap_3
XFILLER_47_329 VGND VGND VPWR VPWR sky130_fd_sc_hd__fill_4
XFILLER_55_373 VPWR VGND VPWR VGND sky130_ef_sc_hd__decap_40_12
XTAP_TAPCELL_ROW_2_152 VGND VPWR sky130_fd_sc_hd__tapvpwrvgnd_1
XFILLER_15_237 VPWR VGND VPWR VGND sky130_ef_sc_hd__decap_40_12
XPHY_EDGE_ROW_61_Right_61 VGND VGND VPWR VPWR sky130_fd_sc_hd__decap_3
XPHY_EDGE_ROW_36_Left_101 VGND VGND VPWR VPWR sky130_fd_sc_hd__decap_3
XFILLER_23_51 VGND VGND VPWR VPWR sky130_fd_sc_hd__fill_4
XFILLER_23_281 VGND VGND VPWR VPWR sky130_fd_sc_hd__fill_4
XFILLER_2_141 VPWR VGND VPWR VGND sky130_ef_sc_hd__decap_40_12
XFILLER_48_81 VGND VGND VPWR VPWR sky130_fd_sc_hd__fill_2
XPHY_EDGE_ROW_45_Left_110 VGND VGND VPWR VPWR sky130_fd_sc_hd__decap_3
XFILLER_38_307 VGND VGND VPWR VPWR sky130_fd_sc_hd__fill_1
XFILLER_0_55 VGND VGND VPWR VPWR sky130_fd_sc_hd__fill_1
XTAP_TAPCELL_ROW_16_254 VGND VPWR sky130_fd_sc_hd__tapvpwrvgnd_1
XFILLER_28_29 VPWR VGND VPWR VGND sky130_ef_sc_hd__decap_40_12
XFILLER_64_181 VPWR VGND VPWR VGND sky130_ef_sc_hd__decap_40_12
XFILLER_56_137 VGND VGND VPWR VPWR sky130_fd_sc_hd__fill_2
XFILLER_52_321 VPWR VGND VPWR VGND sky130_ef_sc_hd__decap_40_12
XFILLER_60_27 VGND VGND VPWR VPWR sky130_fd_sc_hd__fill_1
XFILLER_52_365 VPWR VGND VPWR VGND sky130_ef_sc_hd__decap_40_12
Xclkbuf_3_0__f_clk clkbuf_0_clk/X VGND VGND VPWR VPWR _545_/CLK sky130_fd_sc_hd__clkbuf_16
XFILLER_47_137 VPWR VGND VPWR VGND sky130_ef_sc_hd__decap_40_12
XFILLER_55_181 VPWR VGND VPWR VGND sky130_ef_sc_hd__decap_40_12
XFILLER_34_83 VGND VGND VPWR VPWR sky130_fd_sc_hd__fill_1
XFILLER_7_277 VGND VGND VPWR VPWR sky130_fd_sc_hd__fill_2
XFILLER_11_273 VGND VGND VPWR VPWR sky130_fd_sc_hd__fill_4
XTAP_TAPCELL_ROW_21_290 VGND VPWR sky130_fd_sc_hd__tapvpwrvgnd_1
XFILLER_38_137 VGND VGND VPWR VPWR sky130_fd_sc_hd__fill_2
XFILLER_19_395 VGND VGND VPWR VPWR sky130_fd_sc_hd__fill_1
XFILLER_34_365 VGND VGND VPWR VPWR sky130_fd_sc_hd__fill_1
XFILLER_39_39 VPWR VGND VPWR VGND sky130_ef_sc_hd__decap_40_12
XFILLER_29_137 VPWR VGND VPWR VGND sky130_ef_sc_hd__decap_40_12
XPHY_EDGE_ROW_2_Right_2 VGND VGND VPWR VPWR sky130_fd_sc_hd__decap_3
XFILLER_55_27 VPWR VGND VPWR VGND sky130_ef_sc_hd__decap_40_12
XFILLER_52_195 VGND VGND VPWR VPWR sky130_fd_sc_hd__fill_1
XTAP_TAPCELL_ROW_35_382 VGND VPWR sky130_fd_sc_hd__tapvpwrvgnd_1
XTAP_TAPCELL_ROW_27_327 VGND VPWR sky130_fd_sc_hd__tapvpwrvgnd_1
XFILLER_40_346 VGND VGND VPWR VPWR sky130_fd_sc_hd__fill_1
XFILLER_20_41 VPWR VGND VPWR VGND sky130_ef_sc_hd__decap_40_12
XFILLER_20_85 VPWR VGND VPWR VGND sky130_ef_sc_hd__decap_40_12
XFILLER_63_405 VGND VGND VPWR VPWR sky130_fd_sc_hd__fill_2
Xhold61 _305_/X VGND VGND VPWR VPWR _492_/D sky130_fd_sc_hd__dlygate4sd3_1
Xhold50 _255_/X VGND VGND VPWR VPWR hold50/X sky130_fd_sc_hd__dlygate4sd3_1
Xhold72 _324_/X VGND VGND VPWR VPWR hold72/X sky130_fd_sc_hd__dlygate4sd3_1
Xhold94 _321_/X VGND VGND VPWR VPWR hold94/X sky130_fd_sc_hd__dlygate4sd3_1
XFILLER_16_321 VPWR VGND VPWR VGND sky130_ef_sc_hd__decap_40_12
Xhold83 _462_/Y VGND VGND VPWR VPWR _556_/D sky130_fd_sc_hd__dlygate4sd3_1
XFILLER_45_93 VPWR VGND VPWR VGND sky130_ef_sc_hd__decap_40_12
XFILLER_31_346 VGND VGND VPWR VPWR sky130_fd_sc_hd__fill_2
XFILLER_31_313 VGND VGND VPWR VPWR sky130_fd_sc_hd__fill_4
XFILLER_16_365 VPWR VGND VPWR VGND sky130_ef_sc_hd__decap_40_12
XFILLER_61_81 VPWR VGND VPWR VGND sky130_ef_sc_hd__decap_40_12
XFILLER_6_65 VPWR VGND VPWR VGND sky130_ef_sc_hd__decap_40_12
XFILLER_54_405 VGND VGND VPWR VPWR sky130_fd_sc_hd__fill_2
XTAP_TAPCELL_ROW_49_485 VGND VPWR sky130_fd_sc_hd__tapvpwrvgnd_1
XFILLER_34_184 VGND VGND VPWR VPWR sky130_fd_sc_hd__fill_2
XFILLER_19_181 VPWR VGND VPWR VGND sky130_ef_sc_hd__decap_40_12
XTAP_TAPCELL_ROW_24_308 VGND VPWR sky130_fd_sc_hd__tapvpwrvgnd_1
XFILLER_34_195 VGND VGND VPWR VPWR sky130_fd_sc_hd__fill_1
XTAP_TAPCELL_ROW_32_363 VGND VPWR sky130_fd_sc_hd__tapvpwrvgnd_1
XFILLER_22_335 VGND VGND VPWR VPWR sky130_fd_sc_hd__fill_1
XFILLER_1_217 VGND VGND VPWR VPWR sky130_fd_sc_hd__fill_4
XFILLER_57_221 VGND VGND VPWR VPWR sky130_fd_sc_hd__fill_2
XFILLER_45_405 VGND VGND VPWR VPWR sky130_fd_sc_hd__fill_2
X_381_ _382_/A _385_/C VGND VGND VPWR VPWR _383_/B sky130_fd_sc_hd__or2_1
XFILLER_40_165 VGND VGND VPWR VPWR sky130_fd_sc_hd__fill_4
XFILLER_40_121 VPWR VGND VPWR VGND sky130_ef_sc_hd__decap_40_12
XFILLER_9_317 VPWR VGND VPWR VGND sky130_ef_sc_hd__decap_40_12
XFILLER_13_335 VGND VGND VPWR VPWR sky130_fd_sc_hd__fill_1
X_450_ _452_/B _458_/C _449_/Y VGND VGND VPWR VPWR _450_/Y sky130_fd_sc_hd__a21oi_1
Xoutput5 _492_/Q VGND VGND VPWR VPWR led[2] sky130_fd_sc_hd__buf_2
XFILLER_31_51 VGND VGND VPWR VPWR sky130_fd_sc_hd__fill_4
XFILLER_48_221 VPWR VGND VPWR VGND sky130_ef_sc_hd__decap_40_12
XFILLER_63_279 VGND VGND VPWR VPWR sky130_fd_sc_hd__fill_1
XFILLER_56_81 VGND VGND VPWR VPWR sky130_fd_sc_hd__fill_2
XFILLER_48_265 VPWR VGND VPWR VGND sky130_ef_sc_hd__decap_40_12
XFILLER_8_361 VGND VGND VPWR VPWR sky130_fd_sc_hd__fill_2
XFILLER_16_195 VGND VGND VPWR VPWR sky130_fd_sc_hd__fill_1
XTAP_TAPCELL_ROW_37_400 VGND VPWR sky130_fd_sc_hd__tapvpwrvgnd_1
XFILLER_36_29 VPWR VGND VPWR VGND sky130_ef_sc_hd__decap_40_12
XFILLER_10_305 VGND VGND VPWR VPWR sky130_fd_sc_hd__fill_2
XFILLER_22_121 VPWR VGND VPWR VGND sky130_ef_sc_hd__decap_40_12
XFILLER_22_165 VPWR VGND VPWR VGND sky130_ef_sc_hd__decap_40_12
XFILLER_6_309 VPWR VGND VPWR VGND sky130_ef_sc_hd__decap_40_12
X_502_ _516_/CLK _502_/D VGND VGND VPWR VPWR _502_/Q sky130_fd_sc_hd__dfxtp_1
X_433_ _433_/A _433_/B VGND VGND VPWR VPWR _445_/A sky130_fd_sc_hd__nor2_1
XFILLER_60_249 VGND VGND VPWR VPWR sky130_fd_sc_hd__fill_2
XFILLER_42_83 VGND VGND VPWR VPWR sky130_fd_sc_hd__fill_1
X_364_ _364_/A _376_/B VGND VGND VPWR VPWR _364_/X sky130_fd_sc_hd__or2_1
X_295_ _486_/Q _306_/B VGND VGND VPWR VPWR _333_/A sky130_fd_sc_hd__and2_2
XFILLER_9_125 VPWR VGND VPWR VGND sky130_ef_sc_hd__decap_40_12
XFILLER_9_169 VPWR VGND VPWR VGND sky130_ef_sc_hd__decap_40_12
XFILLER_13_165 VGND VGND VPWR VPWR sky130_fd_sc_hd__fill_2
XFILLER_36_224 VGND VGND VPWR VPWR sky130_fd_sc_hd__fill_4
XFILLER_3_55 VGND VGND VPWR VPWR sky130_fd_sc_hd__fill_1
XFILLER_51_249 VPWR VGND VPWR VGND sky130_ef_sc_hd__decap_40_12
XFILLER_51_205 VPWR VGND VPWR VGND sky130_ef_sc_hd__decap_40_12
XFILLER_59_349 VPWR VGND VPWR VGND sky130_ef_sc_hd__decap_40_12
XFILLER_59_305 VPWR VGND VPWR VGND sky130_ef_sc_hd__decap_40_12
XFILLER_63_27 VPWR VGND VPWR VGND sky130_ef_sc_hd__decap_40_12
XTAP_TAPCELL_ROW_57_539 VGND VPWR sky130_fd_sc_hd__tapvpwrvgnd_1
XFILLER_47_39 VPWR VGND VPWR VGND sky130_ef_sc_hd__decap_40_12
XFILLER_42_205 VPWR VGND VPWR VGND sky130_ef_sc_hd__decap_40_12
XTAP_TAPCELL_ROW_40_417 VGND VPWR sky130_fd_sc_hd__tapvpwrvgnd_1
XFILLER_5_3 VPWR VGND VPWR VGND sky130_ef_sc_hd__decap_40_12
XFILLER_2_345 VPWR VGND VPWR VGND sky130_ef_sc_hd__decap_40_12
XFILLER_2_301 VGND VGND VPWR VPWR sky130_fd_sc_hd__fill_4
XFILLER_6_139 VGND VGND VPWR VPWR sky130_fd_sc_hd__fill_1
XFILLER_12_53 VPWR VGND VPWR VGND sky130_ef_sc_hd__decap_40_12
XFILLER_12_97 VPWR VGND VPWR VGND sky130_ef_sc_hd__decap_40_12
XTAP_TAPCELL_ROW_5_172 VGND VPWR sky130_fd_sc_hd__tapvpwrvgnd_1
XFILLER_2_389 VPWR VGND VPWR VGND sky130_ef_sc_hd__decap_40_12
X_416_ _415_/A _421_/D _428_/A VGND VGND VPWR VPWR _416_/Y sky130_fd_sc_hd__o21ai_1
XFILLER_53_93 VPWR VGND VPWR VGND sky130_ef_sc_hd__decap_40_12
X_347_ _390_/B _509_/Q VGND VGND VPWR VPWR _347_/X sky130_fd_sc_hd__or2_1
X_278_ _278_/A _278_/B _278_/C _278_/D VGND VGND VPWR VPWR _436_/B sky130_fd_sc_hd__nor4_4
XFILLER_38_3 VPWR VGND VPWR VGND sky130_ef_sc_hd__decap_40_12
XFILLER_5_161 VGND VGND VPWR VPWR sky130_fd_sc_hd__fill_4
XFILLER_64_363 VGND VGND VPWR VPWR sky130_fd_sc_hd__fill_1
XFILLER_49_393 VPWR VGND VPWR VGND sky130_ef_sc_hd__decap_40_12
XTAP_TAPCELL_ROW_19_274 VGND VPWR sky130_fd_sc_hd__tapvpwrvgnd_1
XTAP_TAPCELL_ROW_62_575 VGND VPWR sky130_fd_sc_hd__tapvpwrvgnd_1
XFILLER_3_109 VGND VGND VPWR VPWR sky130_fd_sc_hd__fill_2
XFILLER_59_113 VPWR VGND VPWR VGND sky130_ef_sc_hd__decap_40_12
XFILLER_58_27 VGND VGND VPWR VPWR sky130_fd_sc_hd__fill_1
XFILLER_55_385 VGND VGND VPWR VPWR sky130_fd_sc_hd__fill_4
XTAP_TAPCELL_ROW_2_153 VGND VPWR sky130_fd_sc_hd__tapvpwrvgnd_1
XFILLER_15_205 VPWR VGND VPWR VGND sky130_ef_sc_hd__decap_40_12
XFILLER_15_249 VPWR VGND VPWR VGND sky130_ef_sc_hd__decap_40_12
XFILLER_2_197 VPWR VGND VPWR VGND sky130_ef_sc_hd__decap_40_12
XFILLER_2_153 VPWR VGND VPWR VGND sky130_ef_sc_hd__decap_40_12
XFILLER_46_363 VGND VGND VPWR VPWR sky130_fd_sc_hd__fill_1
XFILLER_64_81 VGND VGND VPWR VPWR sky130_fd_sc_hd__fill_2
XFILLER_61_333 VGND VGND VPWR VPWR sky130_fd_sc_hd__fill_2
XTAP_TAPCELL_ROW_16_255 VGND VPWR sky130_fd_sc_hd__tapvpwrvgnd_1
XFILLER_64_193 VGND VGND VPWR VPWR sky130_fd_sc_hd__fill_2
XFILLER_52_377 VPWR VGND VPWR VGND sky130_ef_sc_hd__decap_40_12
XFILLER_52_333 VPWR VGND VPWR VGND sky130_ef_sc_hd__decap_40_12
XFILLER_44_29 VPWR VGND VPWR VGND sky130_ef_sc_hd__decap_40_12
XFILLER_20_285 VGND VGND VPWR VPWR sky130_fd_sc_hd__fill_1
XFILLER_47_149 VPWR VGND VPWR VGND sky130_ef_sc_hd__decap_40_12
XFILLER_47_105 VGND VGND VPWR VPWR sky130_fd_sc_hd__fill_4
XFILLER_18_41 VPWR VGND VPWR VGND sky130_ef_sc_hd__decap_40_12
XFILLER_18_85 VPWR VGND VPWR VGND sky130_ef_sc_hd__decap_40_12
XFILLER_55_193 VPWR VGND VPWR VGND sky130_ef_sc_hd__decap_40_12
XFILLER_50_83 VGND VGND VPWR VPWR sky130_fd_sc_hd__fill_1
XFILLER_7_223 VGND VGND VPWR VPWR sky130_fd_sc_hd__fill_1
XFILLER_59_81 VPWR VGND VPWR VGND sky130_ef_sc_hd__decap_40_12
XFILLER_46_193 VGND VGND VPWR VPWR sky130_fd_sc_hd__fill_2
XFILLER_55_39 VPWR VGND VPWR VGND sky130_ef_sc_hd__decap_40_12
XFILLER_29_149 VPWR VGND VPWR VGND sky130_ef_sc_hd__decap_40_12
XFILLER_29_105 VGND VGND VPWR VPWR sky130_fd_sc_hd__fill_4
XPHY_EDGE_ROW_64_Left_129 VGND VGND VPWR VPWR sky130_fd_sc_hd__decap_3
XFILLER_52_141 VPWR VGND VPWR VGND sky130_ef_sc_hd__decap_40_12
XTAP_TAPCELL_ROW_35_383 VGND VPWR sky130_fd_sc_hd__tapvpwrvgnd_1
XTAP_TAPCELL_ROW_27_328 VGND VPWR sky130_fd_sc_hd__tapvpwrvgnd_1
Xhold40 _562_/Q VGND VGND VPWR VPWR _480_/B sky130_fd_sc_hd__dlygate4sd3_1
XFILLER_20_53 VPWR VGND VPWR VGND sky130_ef_sc_hd__decap_40_12
XFILLER_20_97 VPWR VGND VPWR VGND sky130_ef_sc_hd__decap_40_12
Xhold62 _506_/Q VGND VGND VPWR VPWR _341_/B sky130_fd_sc_hd__dlygate4sd3_1
Xhold51 _388_/X VGND VGND VPWR VPWR _525_/D sky130_fd_sc_hd__dlygate4sd3_1
Xhold73 _325_/X VGND VGND VPWR VPWR _500_/D sky130_fd_sc_hd__dlygate4sd3_1
Xhold95 _322_/X VGND VGND VPWR VPWR _499_/D sky130_fd_sc_hd__dlygate4sd3_1
XFILLER_16_333 VPWR VGND VPWR VGND sky130_ef_sc_hd__decap_40_12
Xhold84 _557_/Q VGND VGND VPWR VPWR _466_/B sky130_fd_sc_hd__dlygate4sd3_1
XFILLER_61_93 VPWR VGND VPWR VGND sky130_ef_sc_hd__decap_40_12
XFILLER_16_377 VPWR VGND VPWR VGND sky130_ef_sc_hd__decap_40_12
XFILLER_3_281 VPWR VGND VPWR VGND sky130_ef_sc_hd__decap_40_12
XFILLER_6_77 VGND VGND VPWR VPWR sky130_fd_sc_hd__fill_4
XFILLER_20_3 VPWR VGND VPWR VGND sky130_ef_sc_hd__decap_40_12
XTAP_TAPCELL_ROW_49_486 VGND VPWR sky130_fd_sc_hd__tapvpwrvgnd_1
XFILLER_34_141 VPWR VGND VPWR VGND sky130_ef_sc_hd__decap_40_12
XFILLER_19_193 VPWR VGND VPWR VGND sky130_ef_sc_hd__decap_40_12
XFILLER_22_314 VGND VGND VPWR VPWR sky130_fd_sc_hd__fill_2
XTAP_TAPCELL_ROW_24_309 VGND VPWR sky130_fd_sc_hd__tapvpwrvgnd_1
XTAP_TAPCELL_ROW_32_364 VGND VPWR sky130_fd_sc_hd__tapvpwrvgnd_1
XFILLER_57_277 VGND VGND VPWR VPWR sky130_fd_sc_hd__fill_2
X_380_ _385_/C _386_/A _380_/C VGND VGND VPWR VPWR _522_/D sky130_fd_sc_hd__and3b_1
XFILLER_40_133 VGND VGND VPWR VPWR sky130_fd_sc_hd__fill_4
XFILLER_9_329 VGND VGND VPWR VPWR sky130_fd_sc_hd__fill_4
Xoutput6 _493_/Q VGND VGND VPWR VPWR led[3] sky130_fd_sc_hd__buf_2
XFILLER_48_277 VPWR VGND VPWR VGND sky130_ef_sc_hd__decap_40_12
XFILLER_48_233 VPWR VGND VPWR VGND sky130_ef_sc_hd__decap_40_12
XFILLER_0_251 VGND VGND VPWR VPWR sky130_fd_sc_hd__fill_1
XFILLER_63_225 VPWR VGND VPWR VGND sky130_ef_sc_hd__decap_40_12
XFILLER_31_111 VGND VGND VPWR VPWR sky130_fd_sc_hd__fill_1
XFILLER_16_141 VPWR VGND VPWR VGND sky130_ef_sc_hd__decap_40_12
XFILLER_31_177 VGND VGND VPWR VPWR sky130_fd_sc_hd__fill_2
.ends
